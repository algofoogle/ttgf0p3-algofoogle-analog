* NGSPICE file created from csringosc_parax.ext - technology: gf180mcuD

.subckt csringosc_parax vin VCC VSS vbiasp vbiasn osc_raw osc_out
X0 a_3260_240# vbiasn.t4 VSS.t18 VSS.t17 nfet_03v3 ad=0.13p pd=1.15u as=0.66p ps=3.4u w=0.6u l=0.3u
X1 a_1400_580# vbiasp.t12 VCC.t9 VCC.t8 pfet_03v3 ad=0.455p pd=3.35u as=3.3p ps=8.2u w=3u l=0.3u
X2 x5.A x4.A a_3260_580# VCC.t22 pfet_03v3 ad=0.8p pd=4.2u as=0.455p ps=3.35u w=1.6u l=0.4u
X3 a_n2674_1338# vin.t4 vbiasp.t4 VSS.t24 nfet_03v3 ad=1.3p pd=5.52u as=1.3p ps=5.52u w=5u l=0.7u
X4 x2.A osc_raw.t3 a_1400_240# VSS.t19 nfet_03v3 ad=0.4p pd=2.6u as=0.13p ps=1.15u w=0.8u l=0.4u
X5 vbiasp.t2 vin.t5 a_n2674_1338# VSS.t23 nfet_03v3 ad=1.3p pd=5.52u as=2.2p ps=10.88u w=5u l=0.7u
X6 a_n2674_1338# a_n2954_216# VSS.t2 ppolyf_u_1k r_width=1u r_length=5u
X7 a_2640_580# vbiasp.t10 VCC.t13 VCC.t12 pfet_03v3 ad=0.455p pd=3.35u as=3.3p ps=8.2u w=3u l=0.3u
X8 a_1400_240# vbiasn.t7 VSS.t10 VSS.t9 nfet_03v3 ad=0.13p pd=1.15u as=0.66p ps=3.4u w=0.6u l=0.3u
X9 x7.A osc_raw.t2 VSS.t21 VSS.t20 nfet_03v3 ad=0.52p pd=3.04u as=0.8p ps=4u w=1u l=0.28u
X10 x2.A osc_raw.t5 a_1400_580# VCC.t18 pfet_03v3 ad=0.8p pd=4.2u as=0.455p ps=3.35u w=1.6u l=0.4u
X11 a_2640_240# vbiasn.t5 VSS.t16 VSS.t15 nfet_03v3 ad=0.13p pd=1.15u as=0.66p ps=3.4u w=0.6u l=0.3u
X12 a_n2674_1338# vin.t0 vbiasp.t0 VSS.t28 nfet_03v3 ad=2.2p pd=10.88u as=1.3p ps=5.52u w=5u l=0.7u
X13 VSS.t12 vbiasn.t1 vbiasn.t2 VSS.t11 nfet_03v3 ad=0.3p pd=2.2u as=0.3p ps=2.2u w=0.6u l=0.3u
X14 vbiasp.t3 vin.t1 a_n2674_1338# VSS.t27 nfet_03v3 ad=1.3p pd=5.52u as=1.3p ps=5.52u w=5u l=0.7u
X15 osc_out.t0 x7.A VCC.t1 VCC.t0 pfet_03v3 ad=1.04p pd=5.04u as=2p ps=6u w=2u l=0.28u
X16 x4.A x3.A a_2640_240# VSS.t6 nfet_03v3 ad=0.4p pd=2.6u as=0.13p ps=1.15u w=0.8u l=0.4u
X17 x3.A x2.A a_2020_240# VSS.t22 nfet_03v3 ad=0.4p pd=2.6u as=0.13p ps=1.15u w=0.8u l=0.4u
X18 a_3880_580# vbiasp.t8 VCC.t17 VCC.t16 pfet_03v3 ad=0.455p pd=3.35u as=3.3p ps=8.2u w=3u l=0.3u
X19 x4.A x3.A a_2640_580# VCC.t3 pfet_03v3 ad=0.8p pd=4.2u as=0.455p ps=3.35u w=1.6u l=0.4u
X20 x3.A x2.A a_2020_580# VCC.t21 pfet_03v3 ad=0.8p pd=4.2u as=0.455p ps=3.35u w=1.6u l=0.4u
X21 osc_raw.t1 x5.A a_3880_240# VSS.t5 nfet_03v3 ad=0.4p pd=2.6u as=0.13p ps=1.15u w=0.8u l=0.4u
X22 a_n2674_1338# vin.t2 vbiasp.t1 VSS.t26 nfet_03v3 ad=1.3p pd=5.52u as=1.3p ps=5.52u w=5u l=0.7u
X23 vbiasp.t5 vin.t3 a_n2674_1338# VSS.t25 nfet_03v3 ad=1.3p pd=5.52u as=1.3p ps=5.52u w=5u l=0.7u
X24 a_3880_240# vbiasn.t3 VSS.t14 VSS.t13 nfet_03v3 ad=0.13p pd=1.15u as=0.66p ps=3.4u w=0.6u l=0.3u
X25 osc_out.t1 x7.A VSS.t4 VSS.t3 nfet_03v3 ad=0.52p pd=3.04u as=0.8p ps=4u w=1u l=0.28u
X26 a_2020_580# vbiasp.t11 VCC.t11 VCC.t10 pfet_03v3 ad=0.455p pd=3.35u as=3.3p ps=8.2u w=3u l=0.3u
X27 osc_raw.t0 x5.A a_3880_580# VCC.t2 pfet_03v3 ad=0.8p pd=4.2u as=0.455p ps=3.35u w=1.6u l=0.4u
X28 VSS.t1 a_n2954_216# VSS.t0 ppolyf_u_1k r_width=1u r_length=5u
X29 vbiasn.t0 vbiasp.t13 VCC.t7 VCC.t6 pfet_03v3 ad=1.5p pd=7u as=1.19p ps=4.62u w=3u l=0.3u
X30 VCC.t5 vbiasp.t6 vbiasp.t7 VCC.t4 pfet_03v3 ad=1.19p pd=4.62u as=2p ps=9u w=4u l=0.28u
X31 a_2020_240# vbiasn.t6 VSS.t8 VSS.t7 nfet_03v3 ad=0.13p pd=1.15u as=0.66p ps=3.4u w=0.6u l=0.3u
X32 a_3260_580# vbiasp.t9 VCC.t15 VCC.t14 pfet_03v3 ad=0.455p pd=3.35u as=3.3p ps=8.2u w=3u l=0.3u
X33 x7.A osc_raw.t4 VCC.t20 VCC.t19 pfet_03v3 ad=1.04p pd=5.04u as=2p ps=6u w=2u l=0.28u
X34 x5.A x4.A a_3260_240# VSS.t29 nfet_03v3 ad=0.4p pd=2.6u as=0.13p ps=1.15u w=0.8u l=0.4u
R0 osc_out.n0 osc_out.t1 5.217
R1 osc_out.n0 osc_out.t0 2.695
R2 osc_out osc_out.n0 0.0455
R3 osc_raw.n1 osc_raw.t4 36.2398
R4 osc_raw.n0 osc_raw.t5 33.398
R5 osc_raw.n1 osc_raw.t2 24.5076
R6 osc_raw.n0 osc_raw.t3 16.0605
R7 osc_raw osc_raw.n3 12.9921
R8 osc_raw osc_raw.n0 8.6935
R9 osc_raw.n2 osc_raw.t1 8.65412
R10 osc_raw.n3 osc_raw.n1 8.35477
R11 osc_raw.n2 osc_raw.t0 3.36696
R12 osc_raw osc_raw.n2 0.0291364
R13 osc_raw.n3 osc_raw 0.00868182
R14 vbiasn.n2 vbiasn.t7 38.4172
R15 vbiasn.n3 vbiasn.t6 38.4172
R16 vbiasn.n4 vbiasn.t5 38.4172
R17 vbiasn.n5 vbiasn.t4 38.4172
R18 vbiasn.n0 vbiasn.t3 38.4172
R19 vbiasn.n1 vbiasn.t1 10.7011
R20 vbiasn.n1 vbiasn.t2 9.188
R21 vbiasn.n1 vbiasn.t0 1.5941
R22 vbiasn vbiasn.n1 1.2155
R23 vbiasn vbiasn.n5 0.6035
R24 vbiasn vbiasn.n4 0.6035
R25 vbiasn vbiasn.n3 0.6035
R26 vbiasn vbiasn.n2 0.6035
R27 vbiasn.n0 vbiasn 0.5135
R28 vbiasn vbiasn.n0 0.4415
R29 vbiasn.n5 vbiasn 0.4415
R30 vbiasn.n4 vbiasn 0.4415
R31 vbiasn.n3 vbiasn 0.4415
R32 vbiasn.n2 vbiasn 0.4415
R33 vbiasp.n9 vbiasp.t6 64.8095
R34 vbiasp.t6 vbiasp.n8 64.8095
R35 vbiasp.n8 vbiasp.t13 54.4125
R36 vbiasp.n10 vbiasp.t12 49.9202
R37 vbiasp.n11 vbiasp.t11 49.9202
R38 vbiasp.n12 vbiasp.t10 49.9202
R39 vbiasp.n13 vbiasp.t9 49.9202
R40 vbiasp.n0 vbiasp.t8 49.9202
R41 vbiasp vbiasp.n9 10.2585
R42 vbiasp.n4 vbiasp.n2 2.16192
R43 vbiasp.n6 vbiasp.n5 2.0617
R44 vbiasp.n4 vbiasp.n3 2.0617
R45 vbiasp.n7 vbiasp.n6 1.25845
R46 vbiasp.n1 vbiasp.t7 1.13175
R47 vbiasp vbiasp.n0 0.5315
R48 vbiasp.n13 vbiasp 0.5315
R49 vbiasp.n12 vbiasp 0.5315
R50 vbiasp.n11 vbiasp 0.5315
R51 vbiasp.n10 vbiasp 0.5315
R52 vbiasp vbiasp.n13 0.5135
R53 vbiasp vbiasp.n12 0.5135
R54 vbiasp vbiasp.n11 0.5135
R55 vbiasp vbiasp.n10 0.5135
R56 vbiasp.n0 vbiasp 0.4235
R57 vbiasp.n9 vbiasp.n1 0.353
R58 vbiasp.n5 vbiasp.t3 0.3281
R59 vbiasp.n5 vbiasp.t0 0.3281
R60 vbiasp.n3 vbiasp.t5 0.3281
R61 vbiasp.n3 vbiasp.t1 0.3281
R62 vbiasp.n2 vbiasp.t2 0.3281
R63 vbiasp.n2 vbiasp.t4 0.3281
R64 vbiasp.n8 vbiasp.n7 0.218
R65 vbiasp.n7 vbiasp.n1 0.1355
R66 vbiasp.n6 vbiasp.n4 0.100727
R67 vin.n3 vin.t0 31.9875
R68 vin.n8 vin.t5 26.0719
R69 vin.n7 vin.t4 26.0719
R70 vin.n6 vin.t3 26.0719
R71 vin.n1 vin.t2 26.0719
R72 vin.n2 vin.t1 26.0719
R73 vin.n2 vin.n1 21.6536
R74 vin.n6 vin.n1 21.6536
R75 vin.n7 vin.n6 21.6536
R76 vin.n8 vin.n7 21.6536
R77 vin.n9 vin.n8 12.5208
R78 vin.n7 vin.n0 12.5005
R79 vin.n6 vin.n5 12.5005
R80 vin.n4 vin.n1 12.5005
R81 vin.n3 vin.n2 5.7611
R82 vin.n4 vin.n3 3.75204
R83 vin.n5 vin.n0 0.336855
R84 vin.n5 vin.n4 0.336855
R85 vin.n9 vin.n0 0.249367
R86 vin vin.n9 0.23225
R87 VCC.n19 VCC.t4 769.813
R88 VCC.t18 VCC.n16 365.385
R89 VCC.n2 VCC.t21 365.385
R90 VCC.n4 VCC.t3 365.385
R91 VCC.n6 VCC.t22 365.385
R92 VCC.n8 VCC.t19 320.271
R93 VCC.n7 VCC.t2 315.142
R94 VCC.n17 VCC.t8 251.457
R95 VCC.n16 VCC.t10 250
R96 VCC.t12 VCC.n2 250
R97 VCC.t14 VCC.n4 250
R98 VCC.t16 VCC.n6 250
R99 VCC.t19 VCC.n7 247.298
R100 VCC.n8 VCC.t0 247.298
R101 VCC.t8 VCC.t18 179.488
R102 VCC.t21 VCC.t10 179.488
R103 VCC.t3 VCC.t12 179.488
R104 VCC.t22 VCC.t14 179.488
R105 VCC.t2 VCC.t16 179.488
R106 VCC.t4 VCC.t6 135.136
R107 VCC.n7 VCC.n0 2.15114
R108 VCC.n9 VCC.n8 2.15114
R109 VCC.n16 VCC.n15 1.45683
R110 VCC.n2 VCC.n1 1.45683
R111 VCC.n4 VCC.n3 1.45683
R112 VCC.n6 VCC.n5 1.45683
R113 VCC.n0 VCC.t20 1.43822
R114 VCC.n9 VCC.t1 1.43822
R115 VCC.n21 VCC.n20 1.26319
R116 VCC VCC.n21 1.02425
R117 VCC.n17 VCC.t9 0.977636
R118 VCC.n5 VCC.t17 0.977636
R119 VCC.n3 VCC.t15 0.977636
R120 VCC.n1 VCC.t13 0.977636
R121 VCC.n15 VCC.t11 0.977636
R122 VCC.n20 VCC.t7 0.758833
R123 VCC.n20 VCC.t5 0.662672
R124 VCC VCC.n9 0.637256
R125 VCC.n10 VCC.n0 0.581006
R126 VCC.n12 VCC 0.428
R127 VCC.n13 VCC 0.428
R128 VCC.n14 VCC 0.428
R129 VCC.n18 VCC 0.428
R130 VCC VCC.n17 0.373706
R131 VCC.n5 VCC 0.373706
R132 VCC.n3 VCC 0.373706
R133 VCC.n1 VCC 0.373706
R134 VCC.n15 VCC 0.373706
R135 VCC.n11 VCC 0.37175
R136 VCC.n19 VCC 0.273962
R137 VCC.n10 VCC 0.203
R138 VCC VCC.n10 0.05675
R139 VCC.n21 VCC.n19 0.0524231
R140 VCC VCC.n18 0.03425
R141 VCC VCC.n11 0.03425
R142 VCC VCC.n12 0.03425
R143 VCC VCC.n13 0.03425
R144 VCC.n14 VCC 0.03425
R145 VCC.n18 VCC 0.0176429
R146 VCC.n11 VCC 0.0176429
R147 VCC.n12 VCC 0.0176429
R148 VCC.n13 VCC 0.0176429
R149 VCC VCC.n14 0.0176429
R150 VSS.n21 VSS.t11 13911.5
R151 VSS.n21 VSS.n20 11339.2
R152 VSS.n36 VSS.n10 1973.21
R153 VSS.n37 VSS.t19 1323.21
R154 VSS.n44 VSS.t22 1323.21
R155 VSS.n45 VSS.t6 1323.21
R156 VSS.n52 VSS.t29 1323.21
R157 VSS.n20 VSS.n10 1194.85
R158 VSS.n53 VSS.t5 1133.74
R159 VSS.t20 VSS.n2 1040.88
R160 VSS.t9 VSS.n36 905.357
R161 VSS.n37 VSS.t7 905.357
R162 VSS.t15 VSS.n44 905.357
R163 VSS.n45 VSS.t17 905.357
R164 VSS.t13 VSS.n52 905.357
R165 VSS.n53 VSS.t20 803.716
R166 VSS.n2 VSS.t3 803.716
R167 VSS.t19 VSS.t9 650
R168 VSS.t7 VSS.t22 650
R169 VSS.t6 VSS.t15 650
R170 VSS.t17 VSS.t29 650
R171 VSS.t5 VSS.t13 650
R172 VSS.t0 VSS.t2 476.44
R173 VSS.n22 VSS.t0 469.981
R174 VSS.n25 VSS.t2 469.635
R175 VSS.t23 VSS.n26 442.409
R176 VSS.n27 VSS.t28 442.409
R177 VSS.t24 VSS.t23 415.183
R178 VSS.t25 VSS.t24 415.183
R179 VSS.t26 VSS.t25 415.183
R180 VSS.t27 VSS.t26 415.183
R181 VSS.t28 VSS.t27 415.183
R182 VSS.t11 VSS.n10 325
R183 VSS.n26 VSS.n25 234.817
R184 VSS.n27 VSS.n21 153.142
R185 VSS.n28 VSS.n19 144.279
R186 VSS.n24 VSS.n22 114.528
R187 VSS.n14 VSS.t12 9.188
R188 VSS.n17 VSS.t1 7.1395
R189 VSS.n2 VSS.n0 7.04921
R190 VSS.n4 VSS.n3 6.3005
R191 VSS.n48 VSS.n47 6.3005
R192 VSS.n8 VSS.n6 6.3005
R193 VSS.n40 VSS.n39 6.3005
R194 VSS.n13 VSS.n11 6.3005
R195 VSS.n35 VSS.n11 6.15467
R196 VSS.n39 VSS.n38 6.15467
R197 VSS.n43 VSS.n6 6.15467
R198 VSS.n47 VSS.n46 6.15467
R199 VSS.n51 VSS.n3 6.15467
R200 VSS.n20 VSS.n14 5.5395
R201 VSS.n36 VSS.n35 5.2005
R202 VSS.n35 VSS.n34 5.2005
R203 VSS.n38 VSS.n37 5.2005
R204 VSS.n38 VSS.n9 5.2005
R205 VSS.n44 VSS.n43 5.2005
R206 VSS.n43 VSS.n42 5.2005
R207 VSS.n46 VSS.n45 5.2005
R208 VSS.n46 VSS.n5 5.2005
R209 VSS.n52 VSS.n51 5.2005
R210 VSS.n51 VSS.n50 5.2005
R211 VSS.n54 VSS.n53 5.2005
R212 VSS.n54 VSS.n1 5.2005
R213 VSS.n55 VSS.n54 4.62633
R214 VSS.n30 VSS.n29 4.55333
R215 VSS.n29 VSS.n18 4.55333
R216 VSS.n32 VSS.n14 4.53088
R217 VSS.n31 VSS.n30 3.51868
R218 VSS.n56 VSS.n55 3.1505
R219 VSS.n30 VSS.n15 3.06246
R220 VSS.n11 VSS.t10 2.888
R221 VSS.n39 VSS.t8 2.888
R222 VSS.n6 VSS.t16 2.888
R223 VSS.n47 VSS.t18 2.888
R224 VSS.n3 VSS.t14 2.888
R225 VSS.n0 VSS.t4 2.86699
R226 VSS.n55 VSS.t21 1.733
R227 VSS.n18 VSS.n17 1.39188
R228 VSS VSS.n0 1.34904
R229 VSS.n33 VSS.n32 1.27224
R230 VSS.n17 VSS.n15 1.17284
R231 VSS VSS.n48 0.445609
R232 VSS.n8 VSS 0.445609
R233 VSS VSS.n40 0.445609
R234 VSS.n13 VSS 0.445609
R235 VSS.n26 VSS.n19 0.433833
R236 VSS.n19 VSS.n16 0.433833
R237 VSS.n28 VSS.n27 0.433833
R238 VSS.n29 VSS.n28 0.433833
R239 VSS.n4 VSS 0.389359
R240 VSS.n22 VSS.n15 0.347167
R241 VSS.n25 VSS.n24 0.347167
R242 VSS.n24 VSS.n23 0.347167
R243 VSS.n30 VSS.n16 0.266409
R244 VSS VSS.n56 0.220609
R245 VSS.n23 VSS.n18 0.205864
R246 VSS.n31 VSS 0.0833947
R247 VSS.n32 VSS.n31 0.0786579
R248 VSS VSS.n1 0.0743587
R249 VSS.n23 VSS.n16 0.0610455
R250 VSS.n50 VSS.n4 0.0435435
R251 VSS.n48 VSS.n5 0.0435435
R252 VSS.n42 VSS.n8 0.0435435
R253 VSS.n40 VSS.n9 0.0435435
R254 VSS.n56 VSS.n1 0.0396304
R255 VSS.n49 VSS 0.03425
R256 VSS VSS.n7 0.03425
R257 VSS.n41 VSS 0.03425
R258 VSS VSS.n12 0.03425
R259 VSS.n34 VSS 0.0337609
R260 VSS.n33 VSS.n13 0.0298478
R261 VSS.n50 VSS.n49 0.0220217
R262 VSS.n7 VSS.n5 0.0220217
R263 VSS.n42 VSS.n41 0.0220217
R264 VSS.n12 VSS.n9 0.0220217
R265 VSS.n34 VSS.n33 0.0141957
R266 VSS.n49 VSS 0.0122391
R267 VSS.n7 VSS 0.0122391
R268 VSS.n41 VSS 0.0122391
R269 VSS.n12 VSS 0.0122391
C0 vin vbiasp 0.82536f
C1 VCC osc_raw 1.56529f
C2 a_3880_240# x5.A 0.00375f
C3 VCC x7.A 0.89309f
C4 x4.A osc_raw 0.09952f
C5 VCC a_2640_580# 0.02546f
C6 x3.A a_2640_240# 0.00375f
C7 x5.A osc_out 0
C8 x5.A a_3260_580# 0.01001f
C9 x4.A a_2640_580# 0.01001f
C10 VCC x3.A 0.94831f
C11 VCC a_2020_580# 0.02546f
C12 osc_raw a_3880_240# 0.00518f
C13 vbiasn vbiasp 0.10609f
C14 x4.A x3.A 0.13386f
C15 VCC vin 0.0089f
C16 vbiasp a_1400_580# 0
C17 osc_raw osc_out 0
C18 x7.A osc_out 0.13699f
C19 osc_raw a_3260_580# 0.00488f
C20 a_n2674_1338# a_n2954_216# 0.01265f
C21 vbiasp a_3880_580# 0
C22 VCC vbiasp 4.70183f
C23 vbiasn VCC 0.43538f
C24 VCC a_1400_580# 0.02546f
C25 vbiasn x4.A 0.02366f
C26 x4.A vbiasp 0.03862f
C27 osc_raw x5.A 0.23833f
C28 x7.A x5.A 0
C29 vin a_n2674_1338# 1.40843f
C30 VCC a_3880_580# 0.02519f
C31 x4.A a_3260_240# 0.00375f
C32 x4.A a_2640_240# 0.00332f
C33 VCC x4.A 0.94831f
C34 osc_raw x2.A 0.22391f
C35 vbiasn osc_out 0
C36 osc_raw x7.A 0.15209f
C37 vbiasp a_3260_580# 0
C38 vbiasn a_n2674_1338# 0
C39 vbiasp a_n2674_1338# 2.78261f
C40 osc_raw a_2640_580# 0.00488f
C41 x3.A x2.A 0.13386f
C42 osc_raw x3.A 0.09938f
C43 a_2020_580# x2.A 0.0079f
C44 osc_raw a_2020_580# 0.00488f
C45 a_2640_580# x3.A 0.0079f
C46 VCC osc_out 0.35628f
C47 vbiasp x5.A 0.03724f
C48 vbiasn x5.A 0.022f
C49 VCC a_3260_580# 0.02546f
C50 VCC a_n2674_1338# 0.01933f
C51 x4.A a_3260_580# 0.0079f
C52 x3.A a_2020_580# 0.01001f
C53 a_2020_240# x2.A 0.00375f
C54 a_2020_240# osc_raw 0.00186f
C55 x5.A a_3260_240# 0.00332f
C56 x5.A a_3880_580# 0.0079f
C57 a_1400_240# x2.A 0.00332f
C58 vbiasn x2.A 0.02377f
C59 vbiasp x2.A 0.03865f
C60 osc_raw a_1400_240# 0.00528f
C61 osc_raw vbiasp 0.08484f
C62 vbiasn osc_raw 0.07315f
C63 vbiasp a_n2954_216# 0.00341f
C64 vbiasn x7.A 0
C65 a_1400_580# x2.A 0.01001f
C66 osc_raw a_1400_580# 0.01261f
C67 VCC x5.A 0.94498f
C68 a_2640_580# vbiasp 0
C69 a_2020_240# x3.A 0.00332f
C70 x4.A x5.A 0.13386f
C71 osc_raw a_3260_240# 0.00186f
C72 osc_raw a_2640_240# 0.00186f
C73 vbiasp x3.A 0.03862f
C74 vbiasn x3.A 0.0237f
C75 osc_raw a_3880_580# 0.01489f
C76 vbiasp a_2020_580# 0
C77 VCC x2.A 0.948f
C78 osc_out VSS 0.3897f
C79 osc_raw VSS 2.58808f
C80 vbiasn VSS 5.29378f
C81 vbiasp VSS 3.50292f
C82 vin VSS 4.04111f
C83 VCC VSS 13.96968f
C84 a_3880_240# VSS 0.00748f
C85 a_3260_240# VSS 0.00745f
C86 a_2640_240# VSS 0.00771f
C87 a_2020_240# VSS 0.00816f
C88 a_1400_240# VSS 0.00944f
C89 x7.A VSS 0.62215f
C90 x5.A VSS 0.4807f
C91 x4.A VSS 0.47769f
C92 x3.A VSS 0.47838f
C93 x2.A VSS 0.49105f
C94 a_1400_580# VSS 0
C95 a_n2674_1338# VSS 2.77653f
C96 a_n2954_216# VSS 0.65102f
C97 VCC.t10 VSS 0.25522f
C98 VCC.t11 VSS 0.06486f
C99 VCC.t20 VSS 0.04117f
C100 VCC.n0 VSS 0.12073f
C101 VCC.t1 VSS 0.04117f
C102 VCC.t0 VSS 0.45319f
C103 VCC.t21 VSS 0.32379f
C104 VCC.t13 VSS 0.06486f
C105 VCC.n1 VSS 0.19013f
C106 VCC.n2 VSS 0.40213f
C107 VCC.t12 VSS 0.25522f
C108 VCC.t3 VSS 0.32379f
C109 VCC.t15 VSS 0.06486f
C110 VCC.n3 VSS 0.19013f
C111 VCC.n4 VSS 0.40213f
C112 VCC.t14 VSS 0.25522f
C113 VCC.t22 VSS 0.32379f
C114 VCC.t17 VSS 0.06486f
C115 VCC.n5 VSS 0.19013f
C116 VCC.n6 VSS 0.40213f
C117 VCC.t16 VSS 0.25522f
C118 VCC.t2 VSS 0.29386f
C119 VCC.n7 VSS 0.33736f
C120 VCC.t19 VSS 0.30357f
C121 VCC.n8 VSS 0.32372f
C122 VCC.n9 VSS 0.13127f
C123 VCC.n10 VSS 0.17408f
C124 VCC.n11 VSS 0.04161f
C125 VCC.n12 VSS 0.04552f
C126 VCC.n13 VSS 0.04552f
C127 VCC.n14 VSS 0.04552f
C128 VCC.n15 VSS 0.19013f
C129 VCC.n16 VSS 0.40213f
C130 VCC.t18 VSS 0.32379f
C131 VCC.t8 VSS 0.25705f
C132 VCC.t9 VSS 0.06486f
C133 VCC.n17 VSS 0.50282f
C134 VCC.n18 VSS 0.04552f
C135 VCC.t6 VSS 0.85289f
C136 VCC.t4 VSS 0.48602f
C137 VCC.n19 VSS 0.67484f
C138 VCC.t7 VSS 0.03809f
C139 VCC.t5 VSS 0.02194f
C140 VCC.n20 VSS 0.16152f
C141 VCC.n21 VSS 0.17242f
C142 vin.n0 VSS 0.03396f
C143 vin.t5 VSS 0.21563f
C144 vin.t4 VSS 0.21563f
C145 vin.t3 VSS 0.21563f
C146 vin.t2 VSS 0.21563f
C147 vin.n1 VSS 0.11017f
C148 vin.t1 VSS 0.21563f
C149 vin.n2 VSS 0.11017f
C150 vin.t0 VSS 0.2348f
C151 vin.n3 VSS 0.09038f
C152 vin.n4 VSS 0.09706f
C153 vin.n5 VSS 0.03747f
C154 vin.n6 VSS 0.11017f
C155 vin.n7 VSS 0.11017f
C156 vin.n8 VSS 0.10296f
C157 vin.n9 VSS 0.06359f
C158 vbiasp.t8 VSS 0.11063f
C159 vbiasp.n0 VSS 0.13313f
C160 vbiasp.t7 VSS 0.21515f
C161 vbiasp.n1 VSS 0.24761f
C162 vbiasp.t4 VSS 0.10111f
C163 vbiasp.t2 VSS 0.10111f
C164 vbiasp.n2 VSS 0.37035f
C165 vbiasp.t1 VSS 0.10111f
C166 vbiasp.t5 VSS 0.10111f
C167 vbiasp.n3 VSS 0.34381f
C168 vbiasp.n4 VSS 1.469f
C169 vbiasp.t0 VSS 0.10111f
C170 vbiasp.t3 VSS 0.10111f
C171 vbiasp.n5 VSS 0.34381f
C172 vbiasp.n6 VSS 1.64918f
C173 vbiasp.n7 VSS 0.17929f
C174 vbiasp.t13 VSS 0.11615f
C175 vbiasp.n8 VSS 0.4155f
C176 vbiasp.t6 VSS 0.1206f
C177 vbiasp.n9 VSS 0.65338f
C178 vbiasp.t12 VSS 0.11063f
C179 vbiasp.n10 VSS 0.1381f
C180 vbiasp.t11 VSS 0.11063f
C181 vbiasp.n11 VSS 0.1381f
C182 vbiasp.t10 VSS 0.11063f
C183 vbiasp.n12 VSS 0.1381f
C184 vbiasp.t9 VSS 0.11063f
C185 vbiasp.n13 VSS 0.1381f
C186 vbiasn.t3 VSS 0.01337f
C187 vbiasn.n0 VSS 0.03548f
C188 vbiasn.t1 VSS 0.02549f
C189 vbiasn.t2 VSS 0.01118f
C190 vbiasn.t0 VSS 0.05545f
C191 vbiasn.n1 VSS 0.25296f
C192 vbiasn.t7 VSS 0.01337f
C193 vbiasn.n2 VSS 0.03701f
C194 vbiasn.t6 VSS 0.01337f
C195 vbiasn.n3 VSS 0.03701f
C196 vbiasn.t5 VSS 0.01337f
C197 vbiasn.n4 VSS 0.03701f
C198 vbiasn.t4 VSS 0.01337f
C199 vbiasn.n5 VSS 0.03701f
C200 osc_raw.t5 VSS 0.12119f
C201 osc_raw.t3 VSS 0.04949f
C202 osc_raw.n0 VSS 0.13387f
C203 osc_raw.t4 VSS 0.08403f
C204 osc_raw.t2 VSS 0.0425f
C205 osc_raw.n1 VSS 0.09385f
C206 osc_raw.t0 VSS 0.13972f
C207 osc_raw.t1 VSS 0.06882f
C208 osc_raw.n2 VSS 0.32102f
C209 osc_raw.n3 VSS 0.73204f
C210 osc_out.t0 VSS 0.13285f
C211 osc_out.t1 VSS 0.06239f
C212 osc_out.n0 VSS 0.27875f
.ends
