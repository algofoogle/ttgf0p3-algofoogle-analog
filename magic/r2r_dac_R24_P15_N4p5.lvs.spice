* NGSPICE file created from r2r_dac_R24_P15_N4p5.ext - technology: gf180mcuD

.subckt inv_P15_N4p5 A Y VSS VCC
X0 VCC A Y VCC pfet_03v3 ad=3.825p pd=16.02u as=2.1375p ps=8.07u w=7.5u l=0.28u
**devattr s=85500,1614 d=156000,3208
X1 Y A VCC VCC pfet_03v3 ad=2.1375p pd=8.07u as=3.825p ps=16.02u w=7.5u l=0.28u
**devattr s=300000,3400 d=85500,1614
X2 Y A VSS VSS nfet_03v3 ad=0.64125p pd=2.82u as=1.1475p ps=5.52u w=2.25u l=0.28u
**devattr s=84000,1300 d=25650,564
X3 VSS A Y VSS nfet_03v3 ad=1.1475p pd=5.52u as=0.64125p ps=2.82u w=2.25u l=0.28u
**devattr s=25650,564 d=46800,1108
.ends

.subckt ppolyf_u_1k_FZFC8D a_40_n2522# a_n2480_2400# a_n1920_2400# a_600_n2522# a_3400_2400#
+ a_2840_2400# a_n1360_n2522# a_n3320_2400# a_n2760_2400# a_3680_2400# a_n2480_n2522#
+ a_n3040_n2522# a_n4160_2400# a_40_2400# a_n3600_2400# a_n4160_n2522# a_3960_2400#
+ a_320_2400# a_n800_n2522# a_2000_n2522# a_1440_n2522# a_n3880_2400# a_2560_n2522#
+ a_3120_n2522# a_3680_n2522# a_600_2400# a_n1640_n2522# a_880_2400# a_n240_2400#
+ a_n2200_n2522# a_n240_n2522# a_n2760_n2522# a_n3320_n2522# a_n3880_n2522# a_n520_2400#
+ a_n4372_n2734# a_1160_2400# a_n1080_2400# a_1720_n2522# a_320_n2522# a_880_n2522#
+ a_n1080_n2522# a_3400_n2522# a_2840_n2522# a_2000_2400# a_n800_2400# a_3960_n2522#
+ a_1440_2400# a_n1360_2400# a_2280_2400# a_n1920_n2522# a_1720_2400# a_1160_n2522#
+ a_n520_n2522# a_n1640_2400# a_n2200_2400# a_n3600_n2522# a_3120_2400# a_2560_2400#
+ a_2280_n2522# a_n3040_2400#
X0 a_1440_2400# a_1440_n2522# a_n4372_n2734# ppolyf_u_1k r_width=1u r_length=24u
X1 a_3960_2400# a_3960_n2522# a_n4372_n2734# ppolyf_u_1k r_width=1u r_length=24u
X2 a_n3040_2400# a_n3040_n2522# a_n4372_n2734# ppolyf_u_1k r_width=1u r_length=24u
X3 a_n520_2400# a_n520_n2522# a_n4372_n2734# ppolyf_u_1k r_width=1u r_length=24u
X4 a_n3600_2400# a_n3600_n2522# a_n4372_n2734# ppolyf_u_1k r_width=1u r_length=24u
X5 a_n1080_2400# a_n1080_n2522# a_n4372_n2734# ppolyf_u_1k r_width=1u r_length=24u
X6 a_2280_2400# a_2280_n2522# a_n4372_n2734# ppolyf_u_1k r_width=1u r_length=24u
X7 a_n3320_2400# a_n3320_n2522# a_n4372_n2734# ppolyf_u_1k r_width=1u r_length=24u
X8 a_1720_2400# a_1720_n2522# a_n4372_n2734# ppolyf_u_1k r_width=1u r_length=24u
X9 a_n3880_2400# a_n3880_n2522# a_n4372_n2734# ppolyf_u_1k r_width=1u r_length=24u
X10 a_n1360_2400# a_n1360_n2522# a_n4372_n2734# ppolyf_u_1k r_width=1u r_length=24u
X11 a_2000_2400# a_2000_n2522# a_n4372_n2734# ppolyf_u_1k r_width=1u r_length=24u
X12 a_n4160_2400# a_n4160_n2522# a_n4372_n2734# ppolyf_u_1k r_width=1u r_length=24u
X13 a_2560_2400# a_2560_n2522# a_n4372_n2734# ppolyf_u_1k r_width=1u r_length=24u
X14 a_n2200_2400# a_n2200_n2522# a_n4372_n2734# ppolyf_u_1k r_width=1u r_length=24u
X15 a_n1640_2400# a_n1640_n2522# a_n4372_n2734# ppolyf_u_1k r_width=1u r_length=24u
X16 a_2840_2400# a_2840_n2522# a_n4372_n2734# ppolyf_u_1k r_width=1u r_length=24u
X17 a_320_2400# a_320_n2522# a_n4372_n2734# ppolyf_u_1k r_width=1u r_length=24u
X18 a_n2480_2400# a_n2480_n2522# a_n4372_n2734# ppolyf_u_1k r_width=1u r_length=24u
X19 a_n1920_2400# a_n1920_n2522# a_n4372_n2734# ppolyf_u_1k r_width=1u r_length=24u
X20 a_3120_2400# a_3120_n2522# a_n4372_n2734# ppolyf_u_1k r_width=1u r_length=24u
X21 a_880_2400# a_880_n2522# a_n4372_n2734# ppolyf_u_1k r_width=1u r_length=24u
X22 a_1160_2400# a_1160_n2522# a_n4372_n2734# ppolyf_u_1k r_width=1u r_length=24u
X23 a_3680_2400# a_3680_n2522# a_n4372_n2734# ppolyf_u_1k r_width=1u r_length=24u
X24 a_n240_2400# a_n240_n2522# a_n4372_n2734# ppolyf_u_1k r_width=1u r_length=24u
X25 a_40_2400# a_40_n2522# a_n4372_n2734# ppolyf_u_1k r_width=1u r_length=24u
X26 a_600_2400# a_600_n2522# a_n4372_n2734# ppolyf_u_1k r_width=1u r_length=24u
X27 a_n2760_2400# a_n2760_n2522# a_n4372_n2734# ppolyf_u_1k r_width=1u r_length=24u
X28 a_n800_2400# a_n800_n2522# a_n4372_n2734# ppolyf_u_1k r_width=1u r_length=24u
X29 a_3400_2400# a_3400_n2522# a_n4372_n2734# ppolyf_u_1k r_width=1u r_length=24u
.ends

.subckt r2r_dac_R24_P15_N4p5 VGND dn[0] dn[1] dn[2] dn[3] dn[4] dn[5] dn[6] dn[7]
+ dn[8] VPWR aout
XXdd0 dn[0] Xdd0/Y VGND VPWR inv_P15_N4p5
XXdd1 dn[1] Xdd1/Y VGND VPWR inv_P15_N4p5
XXdd2 dn[2] Xdd2/Y VGND VPWR inv_P15_N4p5
XXdd3 dn[3] Xdd3/Y VGND VPWR inv_P15_N4p5
XXdd4 dn[4] Xdd4/Y VGND VPWR inv_P15_N4p5
XXdd5 dn[5] Xdd5/Y VGND VPWR inv_P15_N4p5
XXdd7 dn[7] Xdd7/Y VGND VPWR inv_P15_N4p5
XXdd6 dn[6] Xdd6/Y VGND VPWR inv_P15_N4p5
XXdd8 dn[8] Xdd8/Y VGND VPWR inv_P15_N4p5
Xppolyf_u_1k_FZFC8D_0 m1_4370_n3430# m1_1850_1540# m1_2410_1540# m1_4930_n3430# aout
+ m1_6890_1540# m1_2690_n3430# m1_730_1540# m1_730_1540# Xdd8/Y m1_1570_n3430# m1_1010_n3430#
+ VGND m1_4090_1540# m1_730_1540# VGND VGND Xdd4/Y m1_3250_n3430# m1_6050_n3430# m1_4930_n3430#
+ VGND m1_6610_n3430# m1_6610_n3430# m1_7730_n3430# m1_4090_1540# m1_2690_n3430# m1_5210_1540#
+ m1_4090_1540# Xdd1/Y m1_3250_n3430# m1_1570_n3430# m1_1010_n3430# m1_450_n3430#
+ m1_3530_1540# VGND m1_5210_1540# m1_2410_1540# m1_6050_n3430# m1_4370_n3430# m1_4930_n3430#
+ m1_3250_n3430# m1_7730_n3430# Xdd7/Y Xdd6/Y m1_3530_1540# VGND m1_5770_1540# Xdd2/Y
+ m1_5770_1540# m1_1570_n3430# m1_5770_1540# Xdd5/Y Xdd3/Y m1_2410_1540# m1_1850_1540#
+ m1_450_n3430# aout m1_6890_1540# m1_6610_n3430# Xdd0/Y ppolyf_u_1k_FZFC8D
.ends
