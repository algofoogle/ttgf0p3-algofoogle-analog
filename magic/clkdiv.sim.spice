* NGSPICE file created from clkdiv_parax.ext - technology: gf180mcuD

.subckt clkdiv_parax VDD VSS ana_vco_in avo[0] avo[1] avo[2] avo[3] avo[4] avo[5]
+ dac_vco_in dvo[0] dvo[1] dvo[2] dvo[3] dvo[4] dvo[5] uio_oe[0] uio_oe[1] uio_oe[2]
+ uio_oe[3] uio_oe[4] uio_oe[5] uio_oe[6] uio_oe[7]
X0 a_14684_3160# a_14596_3204# VSS VSS nfet_05v0 ad=0.3608p pd=2.52u as=0.3608p ps=2.52u w=0.82u l=1u
X1 a_14572_16839# a_14484_16936# VSS VSS nfet_05v0 ad=0.3608p pd=2.52u as=0.3608p ps=2.52u w=0.82u l=1u
X2 VDD.t1170 a_17260_8999# a_17172_9096# VDD.t1169 pfet_05v0 ad=0.5368p pd=3.32u as=0.5368p ps=3.32u w=1.22u l=1u
X3 VDD.t41 a_16028_4728# a_15940_4772# VDD.t40 pfet_05v0 ad=0.5368p pd=3.32u as=0.5368p ps=3.32u w=1.22u l=1u
X4 VDD.t978 a_13004_9432# a_12916_9476# VDD.t977 pfet_05v0 ad=0.5368p pd=3.32u as=0.5368p ps=3.32u w=1.22u l=1u
X5 VDD.t1890 a_16028_1592# a_15940_1636# VDD.t1889 pfet_05v0 ad=0.5368p pd=3.32u as=0.5368p ps=3.32u w=1.22u l=1u
X6 a_1916_2727# a_1828_2824# VSS VSS nfet_05v0 ad=0.3608p pd=2.52u as=0.3608p ps=2.52u w=0.82u l=1u
X7 a_21964_7431# a_21876_7528# VSS VSS nfet_05v0 ad=0.3608p pd=2.52u as=0.3608p ps=2.52u w=0.82u l=1u
X8 VDD.t1539 a_18380_18407# a_18292_18504# VDD.t1538 pfet_05v0 ad=0.5368p pd=3.32u as=0.5368p ps=3.32u w=1.22u l=1u
X9 a_6396_14136# a_6308_14180# VSS VSS nfet_05v0 ad=0.3608p pd=2.52u as=0.3608p ps=2.52u w=0.82u l=1u
X10 VDD.t306 a_21516_5863# a_21428_5960# VDD.t305 pfet_05v0 ad=0.5368p pd=3.32u as=0.5368p ps=3.32u w=1.22u l=1u
X11 VDD.t93 a_15468_7431# a_15380_7528# VDD.t92 pfet_05v0 ad=0.5368p pd=3.32u as=0.5368p ps=3.32u w=1.22u l=1u
X12 a_20284_17272# a_20196_17316# VSS VSS nfet_05v0 ad=0.3608p pd=2.52u as=0.3608p ps=2.52u w=0.82u l=1u
X13 a_21852_14136# a_21764_14180# VSS VSS nfet_05v0 ad=0.3608p pd=2.52u as=0.3608p ps=2.52u w=0.82u l=1u
X14 VDD.t1990 a_21516_2727# a_21428_2824# VDD.t1989 pfet_05v0 ad=0.5368p pd=3.32u as=0.5368p ps=3.32u w=1.22u l=1u
X15 VDD.t1547 a_14796_9432# a_14708_9476# VDD.t1546 pfet_05v0 ad=0.5368p pd=3.32u as=0.5368p ps=3.32u w=1.22u l=1u
X16 a_6396_11000# a_6308_11044# VSS VSS nfet_05v0 ad=0.3608p pd=2.52u as=0.3608p ps=2.52u w=0.82u l=1u
X17 a_17862_17744# ana_div_chain\[4\]_dff_notouch_.Q VDD.t1696 VDD.t1695 pfet_05v0 ad=0.5368p pd=3.32u as=0.4941p ps=2.03u w=1.22u l=0.5u
X18 VDD.t769 a_19052_15704# a_18964_15748# VDD.t768 pfet_05v0 ad=0.5368p pd=3.32u as=0.5368p ps=3.32u w=1.22u l=1u
X19 VDD.t422 a_11772_14136# a_11684_14180# VDD.t421 pfet_05v0 ad=0.5368p pd=3.32u as=0.5368p ps=3.32u w=1.22u l=1u
X20 VDD.t2074 a_8524_13703# a_8436_13800# VDD.t2073 pfet_05v0 ad=0.5368p pd=3.32u as=0.5368p ps=3.32u w=1.22u l=1u
X21 VDD.t2019 a_1020_6296# a_932_6340# VDD.t1786 pfet_05v0 ad=0.5368p pd=3.32u as=0.5368p ps=3.32u w=1.22u l=1u
X22 VDD.t757 a_1020_3160# a_932_3204# VDD.t485 pfet_05v0 ad=0.5368p pd=3.32u as=0.5368p ps=3.32u w=1.22u l=1u
X23 VDD.t37 a_1468_4295# a_1380_4392# VDD.t36 pfet_05v0 ad=0.5368p pd=3.32u as=0.5368p ps=3.32u w=1.22u l=1u
X24 VDD.t1870 a_1468_1159# a_1380_1256# VDD.t297 pfet_05v0 ad=0.5368p pd=3.32u as=0.5368p ps=3.32u w=1.22u l=1u
X25 a_6844_12568# a_6756_12612# VSS VSS nfet_05v0 ad=0.3608p pd=2.52u as=0.3608p ps=2.52u w=0.82u l=1u
X26 a_19388_9432# a_19300_9476# VSS VSS nfet_05v0 ad=0.3608p pd=2.52u as=0.3608p ps=2.52u w=0.82u l=1u
X27 a_19388_6296# a_19300_6340# VSS VSS nfet_05v0 ad=0.3608p pd=2.52u as=0.3608p ps=2.52u w=0.82u l=1u
X28 dac_div_chain\[4\]_inv_notouch_.I a_11796_16577# VSS VSS nfet_05v0 ad=0.2178p pd=1.87u as=0.153p ps=1.195u w=0.495u l=0.6u
X29 a_16144_15055# a_13924_15047# a_15899_15423# VSS nfet_05v0 ad=43.2f pd=0.6u as=93.59999f ps=0.88u w=0.36u l=0.6u
X30 a_7292_3160# a_7204_3204# VSS VSS nfet_05v0 ad=0.3608p pd=2.52u as=0.3608p ps=2.52u w=0.82u l=1u
X31 a_6284_15271# a_6196_15368# VSS VSS nfet_05v0 ad=0.3608p pd=2.52u as=0.3608p ps=2.52u w=0.82u l=1u
X32 a_2364_7864# a_2276_7908# VSS VSS nfet_05v0 ad=0.3608p pd=2.52u as=0.3608p ps=2.52u w=0.82u l=1u
X33 a_6284_12135# a_6196_12232# VSS VSS nfet_05v0 ad=0.3608p pd=2.52u as=0.3608p ps=2.52u w=0.82u l=1u
X34 a_2364_4728# a_2276_4772# VSS VSS nfet_05v0 ad=0.3608p pd=2.52u as=0.3608p ps=2.52u w=0.82u l=1u
X35 a_16812_4295# a_16724_4392# VSS VSS nfet_05v0 ad=0.3608p pd=2.52u as=0.3608p ps=2.52u w=0.82u l=1u
X36 a_18156_2727# a_18068_2824# VSS VSS nfet_05v0 ad=0.3608p pd=2.52u as=0.3608p ps=2.52u w=0.82u l=1u
X37 a_6732_13703# a_6644_13800# VSS VSS nfet_05v0 ad=0.3608p pd=2.52u as=0.3608p ps=2.52u w=0.82u l=1u
X38 VDD.t376 a_8076_7431# a_7988_7528# VDD.t375 pfet_05v0 ad=0.5368p pd=3.32u as=0.5368p ps=3.32u w=1.22u l=1u
X39 a_16740_16623# a_15940_16615# VSS VSS nfet_05v0 ad=43.2f pd=0.6u as=0.1584p ps=1.6u w=0.36u l=0.6u
X40 a_20620_16839# a_20532_16936# VSS VSS nfet_05v0 ad=0.3608p pd=2.52u as=0.3608p ps=2.52u w=0.82u l=1u
X41 VDD.t467 a_12780_15271# a_12692_15368# VDD.t466 pfet_05v0 ad=0.5368p pd=3.32u as=0.5368p ps=3.32u w=1.22u l=1u
X42 a_3708_13703# a_3620_13800# VSS VSS nfet_05v0 ad=0.3608p pd=2.52u as=0.3608p ps=2.52u w=0.82u l=1u
X43 a_20284_1592# a_20196_1636# VSS VSS nfet_05v0 ad=0.3608p pd=2.52u as=0.3608p ps=2.52u w=0.82u l=1u
X44 VSS a_14880_11875# a_14776_11919# VSS nfet_05v0 ad=0.2637p pd=1.825u as=93.59999f ps=0.88u w=0.36u l=0.6u
X45 a_18044_14136# a_17956_14180# VSS VSS nfet_05v0 ad=0.3608p pd=2.52u as=0.3608p ps=2.52u w=0.82u l=1u
X46 a_14336_15368# a_13924_15047# VSS VSS nfet_05v0 ad=0.1782p pd=1.69u as=0.1053p ps=0.925u w=0.405u l=0.6u
X47 a_18044_11000# a_17956_11044# VSS VSS nfet_05v0 ad=0.3608p pd=2.52u as=0.3608p ps=2.52u w=0.82u l=1u
X48 VDD.t1066 a_18604_12135# a_18516_12232# VDD.t1065 pfet_05v0 ad=0.5368p pd=3.32u as=0.5368p ps=3.32u w=1.22u l=1u
X49 a_4044_18407# a_3956_18504# VSS VSS nfet_05v0 ad=0.3608p pd=2.52u as=0.3608p ps=2.52u w=0.82u l=1u
X50 VDD.t1358 a_6844_15704# a_6756_15748# VDD.t1357 pfet_05v0 ad=0.5368p pd=3.32u as=0.5368p ps=3.32u w=1.22u l=1u
X51 VDD.t823 a_2364_14136# a_2276_14180# VDD.t822 pfet_05v0 ad=0.5368p pd=3.32u as=0.5368p ps=3.32u w=1.22u l=1u
X52 a_3708_1592# a_3620_1636# VSS VSS nfet_05v0 ad=0.3608p pd=2.52u as=0.3608p ps=2.52u w=0.82u l=1u
X53 VDD.t1980 a_21404_18407# a_21316_18504# VDD.t1979 pfet_05v0 ad=0.5368p pd=3.32u as=0.5368p ps=3.32u w=1.22u l=1u
X54 VDD.t1674 a_2364_11000# a_2276_11044# VDD.t557 pfet_05v0 ad=0.5368p pd=3.32u as=0.5368p ps=3.32u w=1.22u l=1u
X55 a_21628_3160# a_21540_3204# VSS VSS nfet_05v0 ad=0.3608p pd=2.52u as=0.3608p ps=2.52u w=0.82u l=1u
X56 VDD.t1737 a_2364_7864# a_2276_7908# VDD.t1736 pfet_05v0 ad=0.5368p pd=3.32u as=0.5368p ps=3.32u w=1.22u l=1u
X57 a_9420_4295# a_9332_4392# VSS VSS nfet_05v0 ad=0.3608p pd=2.52u as=0.3608p ps=2.52u w=0.82u l=1u
X58 VDD.t2018 a_19948_7431# a_19860_7528# VDD.t2017 pfet_05v0 ad=0.5368p pd=3.32u as=0.5368p ps=3.32u w=1.22u l=1u
X59 a_10876_18407# a_10788_18504# VSS VSS nfet_05v0 ad=0.3608p pd=2.52u as=0.3608p ps=2.52u w=0.82u l=1u
X60 VDD.t59 a_5500_6296# a_5412_6340# VDD.t58 pfet_05v0 ad=0.5368p pd=3.32u as=0.5368p ps=3.32u w=1.22u l=1u
X61 VDD.t2102 a_5500_3160# a_5412_3204# VDD.t2101 pfet_05v0 ad=0.5368p pd=3.32u as=0.5368p ps=3.32u w=1.22u l=1u
X62 a_16192_15011# a_15899_15423# VDD.t460 VDD.t459 pfet_05v0 ad=0.352p pd=2.48u as=0.23p ps=1.54u w=0.8u l=0.5u
X63 VDD.t1072 a_17280_16579# a_17252_16991# VDD.t1071 pfet_05v0 ad=0.1044p pd=0.94u as=43.2f ps=0.6u w=0.36u l=0.5u
X64 a_7292_17272# a_7204_17316# VSS VSS nfet_05v0 ad=0.3608p pd=2.52u as=0.3608p ps=2.52u w=0.82u l=1u
X65 a_8860_14136# a_8772_14180# VSS VSS nfet_05v0 ad=0.3608p pd=2.52u as=0.3608p ps=2.52u w=0.82u l=1u
X66 a_16364_7431# a_16276_7528# VSS VSS nfet_05v0 ad=0.3608p pd=2.52u as=0.3608p ps=2.52u w=0.82u l=1u
X67 a_22076_11000# a_21988_11044# VSS VSS nfet_05v0 ad=0.3608p pd=2.52u as=0.3608p ps=2.52u w=0.82u l=1u
X68 VDD.t1590 a_9980_11000# a_9892_11044# VDD.t1589 pfet_05v0 ad=0.5368p pd=3.32u as=0.5368p ps=3.32u w=1.22u l=1u
X69 VDD.t570 a_15356_17272# a_15268_17316# VDD.t569 pfet_05v0 ad=0.5368p pd=3.32u as=0.5368p ps=3.32u w=1.22u l=1u
X70 a_18160_16623# a_15940_16615# a_17915_16991# VSS nfet_05v0 ad=43.2f pd=0.6u as=93.59999f ps=0.88u w=0.36u l=0.6u
X71 a_6844_7864# a_6756_7908# VSS VSS nfet_05v0 ad=0.3608p pd=2.52u as=0.3608p ps=2.52u w=0.82u l=1u
X72 a_6844_4728# a_6756_4772# VSS VSS nfet_05v0 ad=0.3608p pd=2.52u as=0.3608p ps=2.52u w=0.82u l=1u
X73 a_7740_15704# a_7652_15748# VSS VSS nfet_05v0 ad=0.3608p pd=2.52u as=0.3608p ps=2.52u w=0.82u l=1u
X74 VDD.t1648 a_11748_12568# a_11144_12971# VDD.t1647 pfet_05v0 ad=0.23p pd=1.54u as=0.352p ps=2.48u w=0.8u l=0.5u
X75 a_12780_4295# a_12692_4392# VSS VSS nfet_05v0 ad=0.3608p pd=2.52u as=0.3608p ps=2.52u w=0.82u l=1u
X76 a_18492_14136# a_18404_14180# VSS VSS nfet_05v0 ad=0.3608p pd=2.52u as=0.3608p ps=2.52u w=0.82u l=1u
X77 a_18492_1592# a_18404_1636# VSS VSS nfet_05v0 ad=0.3608p pd=2.52u as=0.3608p ps=2.52u w=0.82u l=1u
X78 a_20848_13097# a_18628_13096# a_20603_12729# VSS nfet_05v0 ad=43.2f pd=0.6u as=93.59999f ps=0.88u w=0.36u l=0.6u
X79 a_16352_16936# a_15940_16615# VSS VSS nfet_05v0 ad=0.1782p pd=1.69u as=0.1053p ps=0.925u w=0.405u l=0.6u
X80 a_18492_11000# a_18404_11044# VSS VSS nfet_05v0 ad=0.3608p pd=2.52u as=0.3608p ps=2.52u w=0.82u l=1u
X81 a_15468_11000# a_15380_11044# VSS VSS nfet_05v0 ad=0.3608p pd=2.52u as=0.3608p ps=2.52u w=0.82u l=1u
X82 a_13340_3160# a_13252_3204# VSS VSS nfet_05v0 ad=0.3608p pd=2.52u as=0.3608p ps=2.52u w=0.82u l=1u
X83 VDD.t1978 a_21852_18407# a_21764_18504# VDD.t1977 pfet_05v0 ad=0.5368p pd=3.32u as=0.5368p ps=3.32u w=1.22u l=1u
X84 VSS a_8792_10261# dac_div_chain\[2\]_load_slew11.Z VSS nfet_05v0 ad=0.153p pd=1.195u as=0.2178p ps=1.87u w=0.495u l=0.6u
X85 a_19040_12683# a_18628_13096# VSS VSS nfet_05v0 ad=0.1782p pd=1.69u as=0.1053p ps=0.925u w=0.405u l=0.6u
X86 VDD.t1396 a_6844_7864# a_6756_7908# VDD.t1395 pfet_05v0 ad=0.5368p pd=3.32u as=0.5368p ps=3.32u w=1.22u l=1u
X87 a_15916_12568# a_15828_12612# VSS VSS nfet_05v0 ad=0.3608p pd=2.52u as=0.3608p ps=2.52u w=0.82u l=1u
X88 a_13120_16233# a_10900_16232# a_12875_15865# VSS nfet_05v0 ad=43.2f pd=0.6u as=93.59999f ps=0.88u w=0.36u l=0.6u
X89 a_12192_13053# dac_div_chain\[1\]_dff_notouch_.CLK VDD.t1588 VDD.t1587 pfet_05v0 ad=0.3806p pd=2.61u as=0.2249p ps=1.385u w=0.865u l=0.5u
X90 a_19836_3160# a_19748_3204# VSS VSS nfet_05v0 ad=0.3608p pd=2.52u as=0.3608p ps=2.52u w=0.82u l=1u
X91 a_20620_7431# a_20532_7528# VSS VSS nfet_05v0 ad=0.3608p pd=2.52u as=0.3608p ps=2.52u w=0.82u l=1u
X92 a_18380_15271# a_18292_15368# VSS VSS nfet_05v0 ad=0.3608p pd=2.52u as=0.3608p ps=2.52u w=0.82u l=1u
X93 a_15468_4295# a_15380_4392# VSS VSS nfet_05v0 ad=0.3608p pd=2.52u as=0.3608p ps=2.52u w=0.82u l=1u
X94 VDD.t871 a_14124_7431# a_14036_7528# VDD.t870 pfet_05v0 ad=0.5368p pd=3.32u as=0.5368p ps=3.32u w=1.22u l=1u
X95 VDD.t1178 a_13452_9432# a_13364_9476# VDD.t1177 pfet_05v0 ad=0.5368p pd=3.32u as=0.5368p ps=3.32u w=1.22u l=1u
X96 VDD.t1106 a_10204_17272# a_10116_17316# VDD.t1105 pfet_05v0 ad=0.5368p pd=3.32u as=0.5368p ps=3.32u w=1.22u l=1u
X97 VDD.t2015 a_11548_6296# a_11460_6340# VDD.t2014 pfet_05v0 ad=0.5368p pd=3.32u as=0.5368p ps=3.32u w=1.22u l=1u
X98 a_16028_3160# a_15940_3204# VSS VSS nfet_05v0 ad=0.3608p pd=2.52u as=0.3608p ps=2.52u w=0.82u l=1u
X99 VDD.t2021 a_11548_3160# a_11460_3204# VDD.t2020 pfet_05v0 ad=0.5368p pd=3.32u as=0.5368p ps=3.32u w=1.22u l=1u
X100 VDD.t168 a_21964_5863# a_21876_5960# VDD.t167 pfet_05v0 ad=0.5368p pd=3.32u as=0.5368p ps=3.32u w=1.22u l=1u
X101 a_5836_10567# a_5748_10664# VSS VSS nfet_05v0 ad=0.3608p pd=2.52u as=0.3608p ps=2.52u w=0.82u l=1u
X102 VDD.t710 a_21964_2727# a_21876_2824# VDD.t709 pfet_05v0 ad=0.5368p pd=3.32u as=0.5368p ps=3.32u w=1.22u l=1u
X103 a_18044_9432# a_17956_9476# VSS VSS nfet_05v0 ad=0.3608p pd=2.52u as=0.3608p ps=2.52u w=0.82u l=1u
X104 a_18044_6296# a_17956_6340# VSS VSS nfet_05v0 ad=0.3608p pd=2.52u as=0.3608p ps=2.52u w=0.82u l=1u
X105 VDD.t905 a_16700_9432# a_16612_9476# VDD.t904 pfet_05v0 ad=0.5368p pd=3.32u as=0.5368p ps=3.32u w=1.22u l=1u
X106 VDD.t1214 a_2364_16839# a_2276_16936# VDD.t1213 pfet_05v0 ad=0.5368p pd=3.32u as=0.5368p ps=3.32u w=1.22u l=1u
X107 a_1020_7864# a_932_7908# VSS VSS nfet_05v0 ad=0.3608p pd=2.52u as=0.3608p ps=2.52u w=0.82u l=1u
X108 VDD.t1402 a_5948_12568# a_5860_12612# VDD.t1401 pfet_05v0 ad=0.5368p pd=3.32u as=0.5368p ps=3.32u w=1.22u l=1u
X109 a_1020_4728# a_932_4772# VSS VSS nfet_05v0 ad=0.3608p pd=2.52u as=0.3608p ps=2.52u w=0.82u l=1u
X110 a_8076_4295# a_7988_4392# VSS VSS nfet_05v0 ad=0.3608p pd=2.52u as=0.3608p ps=2.52u w=0.82u l=1u
X111 a_19948_12135# a_19860_12232# VSS VSS nfet_05v0 ad=0.3608p pd=2.52u as=0.3608p ps=2.52u w=0.82u l=1u
X112 a_3708_17272# a_3620_17316# VSS VSS nfet_05v0 ad=0.3608p pd=2.52u as=0.3608p ps=2.52u w=0.82u l=1u
X113 VDD.t960 a_1020_10567# a_932_10664# VDD.t959 pfet_05v0 ad=0.5368p pd=3.32u as=0.5368p ps=3.32u w=1.22u l=1u
X114 VDD.t962 a_2812_15271# a_2724_15368# VDD.t961 pfet_05v0 ad=0.5368p pd=3.32u as=0.5368p ps=3.32u w=1.22u l=1u
X115 a_19768_13397# avo[1].t7 VDD.t1967 VDD.t1966 pfet_05v0 ad=0.462p pd=2.98u as=0.4015p ps=1.92u w=1.05u l=0.5u
X116 a_15468_10567# a_15380_10664# VSS VSS nfet_05v0 ad=0.3608p pd=2.52u as=0.3608p ps=2.52u w=0.82u l=1u
X117 VDD.t1090 a_4156_6296# a_4068_6340# VDD.t1089 pfet_05v0 ad=0.5368p pd=3.32u as=0.5368p ps=3.32u w=1.22u l=1u
X118 VDD.t505 a_4156_3160# a_4068_3204# VDD.t504 pfet_05v0 ad=0.5368p pd=3.32u as=0.5368p ps=3.32u w=1.22u l=1u
X119 VDD.t171 a_20732_4728# a_20644_4772# VDD.t170 pfet_05v0 ad=0.5368p pd=3.32u as=0.5368p ps=3.32u w=1.22u l=1u
X120 VSS a_20896_13053# ana_div_chain\[0\]_dff_notouch_.Q VSS nfet_05v0 ad=0.3608p pd=2.52u as=0.2132p ps=1.34u w=0.82u l=0.6u
X121 dac_div_chain\[3\]_inv_notouch_.I a_11264_13443# VDD.t926 VDD.t925 pfet_05v0 ad=0.3172p pd=1.74u as=0.5368p ps=3.32u w=1.22u l=0.5u
X122 VDD.t258 a_20732_1592# a_20644_1636# VDD.t257 pfet_05v0 ad=0.5368p pd=3.32u as=0.5368p ps=3.32u w=1.22u l=1u
X123 a_21068_2727# a_20980_2824# VSS VSS nfet_05v0 ad=0.3608p pd=2.52u as=0.3608p ps=2.52u w=0.82u l=1u
X124 VDD.t1785 a_1020_7864# a_932_7908# VDD.t936 pfet_05v0 ad=0.5368p pd=3.32u as=0.5368p ps=3.32u w=1.22u l=1u
X125 a_19948_4295# a_19860_4392# VSS VSS nfet_05v0 ad=0.3608p pd=2.52u as=0.3608p ps=2.52u w=0.82u l=1u
X126 VDD.t972 a_6396_17272# a_6308_17316# VDD.t971 pfet_05v0 ad=0.5368p pd=3.32u as=0.5368p ps=3.32u w=1.22u l=1u
X127 VDD.t101 a_18604_7431# a_18516_7528# VDD.t100 pfet_05v0 ad=0.5368p pd=3.32u as=0.5368p ps=3.32u w=1.22u l=1u
X128 VDD.t574 a_5052_14136# a_4964_14180# VDD.t573 pfet_05v0 ad=0.5368p pd=3.32u as=0.5368p ps=3.32u w=1.22u l=1u
X129 a_2364_12568# a_2276_12612# VSS VSS nfet_05v0 ad=0.3608p pd=2.52u as=0.3608p ps=2.52u w=0.82u l=1u
X130 a_4940_8999# a_4852_9096# VSS VSS nfet_05v0 ad=0.3608p pd=2.52u as=0.3608p ps=2.52u w=0.82u l=1u
X131 VDD.t2062 a_5052_11000# a_4964_11044# VDD.t2061 pfet_05v0 ad=0.5368p pd=3.32u as=0.5368p ps=3.32u w=1.22u l=1u
X132 VDD.t1952 a_17148_4728# a_17060_4772# VDD.t1951 pfet_05v0 ad=0.5368p pd=3.32u as=0.5368p ps=3.32u w=1.22u l=1u
X133 a_4940_5863# a_4852_5960# VSS VSS nfet_05v0 ad=0.3608p pd=2.52u as=0.3608p ps=2.52u w=0.82u l=1u
X134 a_15020_7431# a_14932_7528# VSS VSS nfet_05v0 ad=0.3608p pd=2.52u as=0.3608p ps=2.52u w=0.82u l=1u
X135 VDD.t1895 a_17148_1592# a_17060_1636# VDD.t1894 pfet_05v0 ad=0.5368p pd=3.32u as=0.5368p ps=3.32u w=1.22u l=1u
X136 VDD.t915 a_7292_9432# a_7204_9476# VDD.t914 pfet_05v0 ad=0.5368p pd=3.32u as=0.5368p ps=3.32u w=1.22u l=1u
X137 a_5500_7864# a_5412_7908# VSS VSS nfet_05v0 ad=0.3608p pd=2.52u as=0.3608p ps=2.52u w=0.82u l=1u
X138 a_20284_9432# a_20196_9476# VSS VSS nfet_05v0 ad=0.3608p pd=2.52u as=0.3608p ps=2.52u w=0.82u l=1u
X139 a_5500_4728# a_5412_4772# VSS VSS nfet_05v0 ad=0.3608p pd=2.52u as=0.3608p ps=2.52u w=0.82u l=1u
X140 a_20284_6296# a_20196_6340# VSS VSS nfet_05v0 ad=0.3608p pd=2.52u as=0.3608p ps=2.52u w=0.82u l=1u
X141 a_21516_10567# a_21428_10664# VSS VSS nfet_05v0 ad=0.3608p pd=2.52u as=0.3608p ps=2.52u w=0.82u l=1u
X142 a_10316_10567# a_10228_10664# VSS VSS nfet_05v0 ad=0.3608p pd=2.52u as=0.3608p ps=2.52u w=0.82u l=1u
X143 a_16908_16623# ana_div_chain\[4\]_inv_notouch_.ZN a_16740_16623# VSS nfet_05v0 ad=0.207p pd=1.51u as=43.2f ps=0.6u w=0.36u l=0.6u
X144 VDD.t1159 a_10788_17316# dvo[4].t4 VDD.t1158 pfet_05v0 ad=0.3782p pd=1.84u as=0.3782p ps=1.84u w=1.22u l=0.5u
X145 VDD.t1905 a_16364_5863# a_16276_5960# VDD.t1904 pfet_05v0 ad=0.5368p pd=3.32u as=0.5368p ps=3.32u w=1.22u l=1u
X146 ana_div_chain\[0\]_dff_notouch_.Q a_20896_13053# VDD.t952 VDD.t951 pfet_05v0 ad=0.3172p pd=1.74u as=0.5368p ps=3.32u w=1.22u l=0.5u
X147 VDD.t1809 a_16364_2727# a_16276_2824# VDD.t1808 pfet_05v0 ad=0.5368p pd=3.32u as=0.5368p ps=3.32u w=1.22u l=1u
X148 a_3708_9432# a_3620_9476# VSS VSS nfet_05v0 ad=0.3608p pd=2.52u as=0.3608p ps=2.52u w=0.82u l=1u
X149 a_9980_12568# a_9892_12612# VSS VSS nfet_05v0 ad=0.3608p pd=2.52u as=0.3608p ps=2.52u w=0.82u l=1u
X150 a_3708_6296# a_3620_6340# VSS VSS nfet_05v0 ad=0.3608p pd=2.52u as=0.3608p ps=2.52u w=0.82u l=1u
X151 a_7628_8999# a_7540_9096# VSS VSS nfet_05v0 ad=0.3608p pd=2.52u as=0.3608p ps=2.52u w=0.82u l=1u
X152 a_7628_5863# a_7540_5960# VSS VSS nfet_05v0 ad=0.3608p pd=2.52u as=0.3608p ps=2.52u w=0.82u l=1u
X153 VDD.t1468 a_2364_15704# a_2276_15748# VDD.t963 pfet_05v0 ad=0.5368p pd=3.32u as=0.5368p ps=3.32u w=1.22u l=1u
X154 a_20844_15704# a_20756_15748# VSS VSS nfet_05v0 ad=0.3608p pd=2.52u as=0.3608p ps=2.52u w=0.82u l=1u
X155 a_12038_17744# dac_div_chain\[4\]_dff_notouch_.Q VSS VSS nfet_05v0 ad=0.3608p pd=2.52u as=0.2911p ps=1.53u w=0.82u l=0.6u
X156 VDD.t136 a_5836_4295# a_5748_4392# VDD.t135 pfet_05v0 ad=0.5368p pd=3.32u as=0.5368p ps=3.32u w=1.22u l=1u
X157 VDD.t1528 a_2812_8999# a_2724_9096# VDD.t1322 pfet_05v0 ad=0.5368p pd=3.32u as=0.5368p ps=3.32u w=1.22u l=1u
X158 a_15748_12287# ana_div_chain\[1\]_inv_notouch_.ZN a_14880_11875# VDD.t846 pfet_05v0 ad=54f pd=0.66u as=0.1872p ps=1.4u w=0.36u l=0.5u
X159 a_21829_1428# a_21709_808# a_21085_808# VDD.t714 pfet_05v0 ad=61.19999f pd=0.7u as=0.3852p ps=2.86u w=0.36u l=0.5u
X160 VDD.t1130 a_18940_4728# a_18852_4772# VDD.t1129 pfet_05v0 ad=0.5368p pd=3.32u as=0.5368p ps=3.32u w=1.22u l=1u
X161 VDD.t1267 a_18940_1592# a_18852_1636# VDD.t1266 pfet_05v0 ad=0.5368p pd=3.32u as=0.5368p ps=3.32u w=1.22u l=1u
X162 VDD.t1476 a_21628_9432# a_21540_9476# VDD.t1475 pfet_05v0 ad=0.5368p pd=3.32u as=0.5368p ps=3.32u w=1.22u l=1u
X163 VDD.t642 a_5500_7864# a_5412_7908# VDD.t641 pfet_05v0 ad=0.5368p pd=3.32u as=0.5368p ps=3.32u w=1.22u l=1u
X164 ana_div_chain\[2\]_inv_notouch_.I a_10340_11575# VDD.t1021 VDD.t1020 pfet_05v0 ad=0.5368p pd=3.32u as=0.4015p ps=1.92u w=1.22u l=0.5u
X165 a_14124_4295# a_14036_4392# VSS VSS nfet_05v0 ad=0.3608p pd=2.52u as=0.3608p ps=2.52u w=0.82u l=1u
X166 a_11868_16233# dac_div_chain\[4\]_dff_notouch_.D a_11700_16233# VSS nfet_05v0 ad=0.207p pd=1.51u as=43.2f ps=0.6u w=0.36u l=0.6u
X167 VDD.t1459 a_1468_13703# a_1380_13800# VDD.t1458 pfet_05v0 ad=0.5368p pd=3.32u as=0.5368p ps=3.32u w=1.22u l=1u
X168 VDD.t1903 a_15132_4728# a_15044_4772# VDD.t1902 pfet_05v0 ad=0.5368p pd=3.32u as=0.5368p ps=3.32u w=1.22u l=1u
X169 VDD.t1602 a_18208_16579# a_18200_16991# VDD.t1601 pfet_05v0 ad=0.23p pd=1.54u as=50.4f ps=0.64u w=0.36u l=0.5u
X170 VDD.t893 a_15132_1592# a_15044_1636# VDD.t253 pfet_05v0 ad=0.5368p pd=3.32u as=0.5368p ps=3.32u w=1.22u l=1u
X171 a_2364_8999# a_2276_9096# VSS VSS nfet_05v0 ad=0.3608p pd=2.52u as=0.3608p ps=2.52u w=0.82u l=1u
X172 a_17565_808# dac_vco_in.t1 VDD.t803 VDD.t802 pfet_05v0 ad=0.3852p pd=2.86u as=0.1116p ps=0.98u w=0.36u l=0.5u
X173 a_2364_5863# a_2276_5960# VSS VSS nfet_05v0 ad=0.3608p pd=2.52u as=0.3608p ps=2.52u w=0.82u l=1u
X174 VDD.t1771 a_10204_6296# a_10116_6340# VDD.t1770 pfet_05v0 ad=0.5368p pd=3.32u as=0.5368p ps=3.32u w=1.22u l=1u
X175 VDD.t1438 a_7628_15271# a_7540_15368# VDD.t1437 pfet_05v0 ad=0.5368p pd=3.32u as=0.5368p ps=3.32u w=1.22u l=1u
X176 a_9739_12287# a_8176_12232# a_9104_11875# VSS nfet_05v0 ad=93.59999f pd=0.88u as=93.59999f ps=0.88u w=0.36u l=0.6u
X177 VDD.t1328 a_22076_17272# a_21988_17316# VDD.t1327 pfet_05v0 ad=0.5368p pd=3.32u as=0.5368p ps=3.32u w=1.22u l=1u
X178 VDD.t515 a_10204_3160# a_10116_3204# VDD.t514 pfet_05v0 ad=0.5368p pd=3.32u as=0.5368p ps=3.32u w=1.22u l=1u
X179 VDD.t410 a_13340_18407# a_13252_18504# VDD.t409 pfet_05v0 ad=0.5368p pd=3.32u as=0.5368p ps=3.32u w=1.22u l=1u
X180 VDD.t146 a_20620_5863# a_20532_5960# VDD.t145 pfet_05v0 ad=0.5368p pd=3.32u as=0.5368p ps=3.32u w=1.22u l=1u
X181 a_19500_7431# a_19412_7528# VSS VSS nfet_05v0 ad=0.3608p pd=2.52u as=0.3608p ps=2.52u w=0.82u l=1u
X182 VDD.t660 a_4940_12135# a_4852_12232# VDD.t659 pfet_05v0 ad=0.5368p pd=3.32u as=0.5368p ps=3.32u w=1.22u l=1u
X183 VDD.t1336 a_8860_17272# a_8772_17316# VDD.t1335 pfet_05v0 ad=0.5368p pd=3.32u as=0.5368p ps=3.32u w=1.22u l=1u
X184 VDD.t1769 a_14572_7431# a_14484_7528# VDD.t1768 pfet_05v0 ad=0.5368p pd=3.32u as=0.5368p ps=3.32u w=1.22u l=1u
X185 VDD.t1798 a_20620_2727# a_20532_2824# VDD.t1797 pfet_05v0 ad=0.5368p pd=3.32u as=0.5368p ps=3.32u w=1.22u l=1u
X186 VDD.t1208 a_1916_12135# a_1828_12232# VDD.t1207 pfet_05v0 ad=0.5368p pd=3.32u as=0.5368p ps=3.32u w=1.22u l=1u
X187 VDD.t2013 a_11996_6296# a_11908_6340# VDD.t2012 pfet_05v0 ad=0.5368p pd=3.32u as=0.5368p ps=3.32u w=1.22u l=1u
X188 a_3260_15704# a_3172_15748# VSS VSS nfet_05v0 ad=0.3608p pd=2.52u as=0.3608p ps=2.52u w=0.82u l=1u
X189 VDD.t2028 a_11996_3160# a_11908_3204# VDD.t2027 pfet_05v0 ad=0.5368p pd=3.32u as=0.5368p ps=3.32u w=1.22u l=1u
X190 a_9868_16839# a_9780_16936# VSS VSS nfet_05v0 ad=0.3608p pd=2.52u as=0.3608p ps=2.52u w=0.82u l=1u
X191 a_21964_10567# a_21876_10664# VSS VSS nfet_05v0 ad=0.3608p pd=2.52u as=0.3608p ps=2.52u w=0.82u l=1u
X192 VDD.t1684 a_19052_8999# a_18964_9096# VDD.t1683 pfet_05v0 ad=0.5368p pd=3.32u as=0.5368p ps=3.32u w=1.22u l=1u
X193 a_10764_10567# a_10676_10664# VSS VSS nfet_05v0 ad=0.3608p pd=2.52u as=0.3608p ps=2.52u w=0.82u l=1u
X194 a_17232_16623# a_16352_16936# a_16908_16623# VSS nfet_05v0 ad=43.2f pd=0.6u as=0.207p ps=1.51u w=0.36u l=0.6u
X195 a_11548_7864# a_11460_7908# VSS VSS nfet_05v0 ad=0.3608p pd=2.52u as=0.3608p ps=2.52u w=0.82u l=1u
X196 a_18492_9432# a_18404_9476# VSS VSS nfet_05v0 ad=0.3608p pd=2.52u as=0.3608p ps=2.52u w=0.82u l=1u
X197 a_11548_4728# a_11460_4772# VSS VSS nfet_05v0 ad=0.3608p pd=2.52u as=0.3608p ps=2.52u w=0.82u l=1u
X198 a_18492_6296# a_18404_6340# VSS VSS nfet_05v0 ad=0.3608p pd=2.52u as=0.3608p ps=2.52u w=0.82u l=1u
X199 a_3708_2727# a_3620_2824# VSS VSS nfet_05v0 ad=0.3608p pd=2.52u as=0.3608p ps=2.52u w=0.82u l=1u
X200 VSS wire12.I a_8996_13479# VSS nfet_05v0 ad=0.1053p pd=0.925u as=0.1782p ps=1.69u w=0.405u l=0.6u
X201 a_21205_1406# a_21085_808# VDD.t251 VDD.t250 pfet_05v0 ad=61.19999f pd=0.7u as=0.379p ps=2.37u w=0.36u l=0.5u
X202 a_8564_11919# a_7764_11911# VSS VSS nfet_05v0 ad=43.2f pd=0.6u as=0.1584p ps=1.6u w=0.36u l=0.6u
X203 a_19596_13097# ana_div_chain\[0\]_dff_notouch_.D a_19472_12729# VDD.t948 pfet_05v0 ad=0.1872p pd=1.4u as=54f ps=0.66u w=0.36u l=0.5u
X204 a_5948_14136# a_5860_14180# VSS VSS nfet_05v0 ad=0.3608p pd=2.52u as=0.3608p ps=2.52u w=0.82u l=1u
X205 a_17260_2727# a_17172_2824# VSS VSS nfet_05v0 ad=0.3608p pd=2.52u as=0.3608p ps=2.52u w=0.82u l=1u
X206 a_10876_1159# a_10788_1256# VSS VSS nfet_05v0 ad=0.3608p pd=2.52u as=0.3608p ps=2.52u w=0.82u l=1u
X207 a_5948_11000# a_5860_11044# VSS VSS nfet_05v0 ad=0.3608p pd=2.52u as=0.3608p ps=2.52u w=0.82u l=1u
X208 VDD.t1624 a_18604_15704# a_18516_15748# VDD.t1623 pfet_05v0 ad=0.5368p pd=3.32u as=0.5368p ps=3.32u w=1.22u l=1u
X209 VDD.t55 a_7180_7431# a_7092_7528# VDD.t54 pfet_05v0 ad=0.5368p pd=3.32u as=0.5368p ps=3.32u w=1.22u l=1u
X210 VSS a_13168_16189# a_13120_16233# VSS nfet_05v0 ad=0.142p pd=1.14u as=43.2f ps=0.6u w=0.36u l=0.6u
X211 VSS a_11256_16533# dac_div_chain\[4\]_dff_notouch_.CLK VSS nfet_05v0 ad=0.153p pd=1.195u as=0.2178p ps=1.87u w=0.495u l=0.6u
X212 VDD.t1745 a_9308_6296# a_9220_6340# VDD.t1744 pfet_05v0 ad=0.5368p pd=3.32u as=0.5368p ps=3.32u w=1.22u l=1u
X213 VDD.t1190 a_9308_3160# a_9220_3204# VDD.t1189 pfet_05v0 ad=0.5368p pd=3.32u as=0.5368p ps=3.32u w=1.22u l=1u
X214 VDD.t540 a_19836_9432# a_19748_9476# VDD.t539 pfet_05v0 ad=0.5368p pd=3.32u as=0.5368p ps=3.32u w=1.22u l=1u
X215 a_12212_15865# a_10900_16232# a_11868_16233# VDD.t1053 pfet_05v0 ad=43.2f pd=0.6u as=0.1872p ps=1.4u w=0.36u l=0.5u
X216 a_4156_7864# a_4068_7908# VSS VSS nfet_05v0 ad=0.3608p pd=2.52u as=0.3608p ps=2.52u w=0.82u l=1u
X217 VDD.t2024 a_11548_7864# a_11460_7908# VDD.t2023 pfet_05v0 ad=0.5368p pd=3.32u as=0.5368p ps=3.32u w=1.22u l=1u
X218 a_18156_10567# a_18068_10664# VSS VSS nfet_05v0 ad=0.3608p pd=2.52u as=0.3608p ps=2.52u w=0.82u l=1u
X219 a_18604_4295# a_18516_4392# VSS VSS nfet_05v0 ad=0.3608p pd=2.52u as=0.3608p ps=2.52u w=0.82u l=1u
X220 a_2812_1592# a_2724_1636# VSS VSS nfet_05v0 ad=0.3608p pd=2.52u as=0.3608p ps=2.52u w=0.82u l=1u
X221 a_4156_4728# a_4068_4772# VSS VSS nfet_05v0 ad=0.3608p pd=2.52u as=0.3608p ps=2.52u w=0.82u l=1u
X222 a_8608_12287# a_8176_12232# VDD.t1534 VDD.t1533 pfet_05v0 ad=54f pd=0.66u as=0.4554p ps=3.25u w=0.36u l=0.5u
X223 a_5836_15271# a_5748_15368# VSS VSS nfet_05v0 ad=0.3608p pd=2.52u as=0.3608p ps=2.52u w=0.82u l=1u
X224 a_5836_12135# a_5748_12232# VSS VSS nfet_05v0 ad=0.3608p pd=2.52u as=0.3608p ps=2.52u w=0.82u l=1u
X225 a_20732_3160# a_20644_3204# VSS VSS nfet_05v0 ad=0.3608p pd=2.52u as=0.3608p ps=2.52u w=0.82u l=1u
X226 VDD.t1663 a_6284_10567# a_6196_10664# VDD.t1662 pfet_05v0 ad=0.5368p pd=3.32u as=0.5368p ps=3.32u w=1.22u l=1u
X227 a_22076_1592# a_21988_1636# VSS VSS nfet_05v0 ad=0.3608p pd=2.52u as=0.3608p ps=2.52u w=0.82u l=1u
X228 a_1916_7431# a_1828_7528# VSS VSS nfet_05v0 ad=0.3608p pd=2.52u as=0.3608p ps=2.52u w=0.82u l=1u
X229 VDD.t1574 a_14460_15704# a_14372_15748# VDD.t1573 pfet_05v0 ad=0.5368p pd=3.32u as=0.5368p ps=3.32u w=1.22u l=1u
X230 VDD.t1551 a_1468_12568# a_1380_12612# VDD.t1209 pfet_05v0 ad=0.5368p pd=3.32u as=0.5368p ps=3.32u w=1.22u l=1u
X231 VDD.t985 a_21516_7431# a_21428_7528# VDD.t984 pfet_05v0 ad=0.5368p pd=3.32u as=0.5368p ps=3.32u w=1.22u l=1u
X232 VDD.t1855 a_21180_11000# a_21092_11044# VDD.t1854 pfet_05v0 ad=0.5368p pd=3.32u as=0.5368p ps=3.32u w=1.22u l=1u
X233 a_14684_1159# a_14596_1256# VSS VSS nfet_05v0 ad=0.3608p pd=2.52u as=0.3608p ps=2.52u w=0.82u l=1u
X234 VDD.t999 a_20620_12135# a_20532_12232# VDD.t998 pfet_05v0 ad=0.5368p pd=3.32u as=0.5368p ps=3.32u w=1.22u l=1u
X235 VSS a_17752_18101# ana_div_chain\[4\]_inv_notouch_.I VSS nfet_05v0 ad=0.153p pd=1.195u as=0.2178p ps=1.87u w=0.495u l=0.6u
X236 VDD.t469 a_12108_15271# a_12020_15368# VDD.t468 pfet_05v0 ad=0.5368p pd=3.32u as=0.5368p ps=3.32u w=1.22u l=1u
X237 VDD.t1723 a_17596_4728# a_17508_4772# VDD.t1722 pfet_05v0 ad=0.5368p pd=3.32u as=0.5368p ps=3.32u w=1.22u l=1u
X238 VDD.t1166 a_1468_8999# a_1380_9096# VDD.t810 pfet_05v0 ad=0.5368p pd=3.32u as=0.5368p ps=3.32u w=1.22u l=1u
X239 VDD.t1519 a_3139_18100# uio_oe[5].t0 VDD.t1518 pfet_05v0 ad=0.5368p pd=3.32u as=0.5368p ps=3.32u w=1.22u l=0.5u
X240 a_19500_15704# a_19412_15748# VSS VSS nfet_05v0 ad=0.3608p pd=2.52u as=0.3608p ps=2.52u w=0.82u l=1u
X241 VDD.t825 a_1916_14136# a_1828_14180# VDD.t824 pfet_05v0 ad=0.5368p pd=3.32u as=0.5368p ps=3.32u w=1.22u l=1u
X242 VDD.t273 a_17596_1592# a_17508_1636# VDD.t272 pfet_05v0 ad=0.5368p pd=3.32u as=0.5368p ps=3.32u w=1.22u l=1u
X243 a_5052_12568# a_4964_12612# VSS VSS nfet_05v0 ad=0.3608p pd=2.52u as=0.3608p ps=2.52u w=0.82u l=1u
X244 VDD.t1897 a_15020_5863# a_14932_5960# VDD.t1896 pfet_05v0 ad=0.5368p pd=3.32u as=0.5368p ps=3.32u w=1.22u l=1u
X245 VDD.t634 a_4156_7864# a_4068_7908# VDD.t309 pfet_05v0 ad=0.5368p pd=3.32u as=0.5368p ps=3.32u w=1.22u l=1u
X246 VDD.t1675 a_1916_11000# a_1828_11044# VDD.t559 pfet_05v0 ad=0.5368p pd=3.32u as=0.5368p ps=3.32u w=1.22u l=1u
X247 VDD.t69 a_15020_2727# a_14932_2824# VDD.t68 pfet_05v0 ad=0.5368p pd=3.32u as=0.5368p ps=3.32u w=1.22u l=1u
X248 a_12324_11161# a_11012_11528# a_11980_11529# VDD.t1016 pfet_05v0 ad=43.2f pd=0.6u as=0.1872p ps=1.4u w=0.36u l=0.5u
X249 avo[4].t0 a_16612_17316# VSS VSS nfet_05v0 ad=0.2132p pd=1.34u as=0.2911p ps=1.53u w=0.82u l=0.6u
X250 a_15292_12287# a_14776_11919# VDD.t1134 VDD.t1133 pfet_05v0 ad=43.2f pd=0.6u as=0.1044p ps=0.94u w=0.36u l=0.5u
X251 a_17148_3160# a_17060_3204# VSS VSS nfet_05v0 ad=0.3608p pd=2.52u as=0.3608p ps=2.52u w=0.82u l=1u
X252 VDD.t1568 a_19768_13397# ana_div_chain\[1\]_dff_notouch_.CLK VDD.t1567 pfet_05v0 ad=0.4015p pd=1.92u as=0.5368p ps=3.32u w=1.22u l=0.5u
X253 a_16252_18407# a_16164_18504# VSS VSS nfet_05v0 ad=0.3608p pd=2.52u as=0.3608p ps=2.52u w=0.82u l=1u
X254 VDD.t222 a_19724_15271# a_19636_15368# VDD.t221 pfet_05v0 ad=0.5368p pd=3.32u as=0.5368p ps=3.32u w=1.22u l=1u
X255 a_18156_7431# a_18068_7528# VSS VSS nfet_05v0 ad=0.3608p pd=2.52u as=0.3608p ps=2.52u w=0.82u l=1u
X256 a_1468_1159# a_1380_1256# VSS VSS nfet_05v0 ad=0.3608p pd=2.52u as=0.3608p ps=2.52u w=0.82u l=1u
X257 a_6844_17272# a_6756_17316# VSS VSS nfet_05v0 ad=0.3608p pd=2.52u as=0.3608p ps=2.52u w=0.82u l=1u
X258 a_21628_11000# a_21540_11044# VSS VSS nfet_05v0 ad=0.3608p pd=2.52u as=0.3608p ps=2.52u w=0.82u l=1u
X259 VDD.t1452 a_14908_17272# a_14820_17316# VDD.t1451 pfet_05v0 ad=0.5368p pd=3.32u as=0.5368p ps=3.32u w=1.22u l=1u
X260 VDD.t1078 a_5052_15704# a_4964_15748# VDD.t1077 pfet_05v0 ad=0.5368p pd=3.32u as=0.5368p ps=3.32u w=1.22u l=1u
X261 VDD.t481 a_9308_14136# a_9220_14180# VDD.t480 pfet_05v0 ad=0.5368p pd=3.32u as=0.5368p ps=3.32u w=1.22u l=1u
X262 VSS a_14432_11875# a_15804_11919# VSS nfet_05v0 ad=0.1584p pd=1.6u as=43.2f ps=0.6u w=0.36u l=0.6u
X263 a_1020_8999# a_932_9096# VSS VSS nfet_05v0 ad=0.3608p pd=2.52u as=0.3608p ps=2.52u w=0.82u l=1u
X264 a_1020_5863# a_932_5960# VSS VSS nfet_05v0 ad=0.3608p pd=2.52u as=0.3608p ps=2.52u w=0.82u l=1u
X265 a_18940_3160# a_18852_3204# VSS VSS nfet_05v0 ad=0.3608p pd=2.52u as=0.3608p ps=2.52u w=0.82u l=1u
X266 a_21516_15271# a_21428_15368# VSS VSS nfet_05v0 ad=0.3608p pd=2.52u as=0.3608p ps=2.52u w=0.82u l=1u
X267 a_14572_4295# a_14484_4392# VSS VSS nfet_05v0 ad=0.3608p pd=2.52u as=0.3608p ps=2.52u w=0.82u l=1u
X268 VDD.t1824 a_15580_4728# a_15492_4772# VDD.t1823 pfet_05v0 ad=0.5368p pd=3.32u as=0.5368p ps=3.32u w=1.22u l=1u
X269 a_18208_16579# a_17915_16991# VSS VSS nfet_05v0 ad=0.176p pd=1.68u as=0.142p ps=1.14u w=0.4u l=0.6u
X270 a_10316_15271# a_10228_15368# VSS VSS nfet_05v0 ad=0.3608p pd=2.52u as=0.3608p ps=2.52u w=0.82u l=1u
X271 a_21516_12135# a_21428_12232# VSS VSS nfet_05v0 ad=0.3608p pd=2.52u as=0.3608p ps=2.52u w=0.82u l=1u
X272 VDD.t320 a_15580_1592# a_15492_1636# VDD.t319 pfet_05v0 ad=0.5368p pd=3.32u as=0.5368p ps=3.32u w=1.22u l=1u
X273 VDD.t1155 a_12038_17744# dvo[5].t5 VDD.t1154 pfet_05v0 ad=0.4941p pd=2.03u as=0.3782p ps=1.84u w=1.22u l=0.5u
X274 VDD.t1832 a_10652_6296# a_10564_6340# VDD.t1831 pfet_05v0 ad=0.5368p pd=3.32u as=0.5368p ps=3.32u w=1.22u l=1u
X275 VDD.t1496 a_7180_13703# a_7092_13800# VDD.t1495 pfet_05v0 ad=0.5368p pd=3.32u as=0.5368p ps=3.32u w=1.22u l=1u
X276 a_15132_3160# a_15044_3204# VSS VSS nfet_05v0 ad=0.3608p pd=2.52u as=0.3608p ps=2.52u w=0.82u l=1u
X277 VDD.t324 a_10652_3160# a_10564_3204# VDD.t323 pfet_05v0 ad=0.5368p pd=3.32u as=0.5368p ps=3.32u w=1.22u l=1u
X278 a_11748_12568# a_12152_12637# a_12096_12729# VDD.t665 pfet_05v0 ad=0.1665p pd=1.285u as=50.4f ps=0.64u w=0.36u l=0.5u
X279 VDD.t596 a_4156_13703# a_4068_13800# VDD.t595 pfet_05v0 ad=0.5368p pd=3.32u as=0.5368p ps=3.32u w=1.22u l=1u
X280 VDD.t1388 a_14124_16839# a_14036_16936# VDD.t1387 pfet_05v0 ad=0.5368p pd=3.32u as=0.5368p ps=3.32u w=1.22u l=1u
X281 a_14776_11919# a_14392_12243# a_13988_12071# VSS nfet_05v0 ad=93.59999f pd=0.88u as=93.59999f ps=0.88u w=0.36u l=0.6u
X282 a_11868_16233# dac_div_chain\[4\]_dff_notouch_.D a_11744_15865# VDD.t933 pfet_05v0 ad=0.1872p pd=1.4u as=54f ps=0.66u w=0.36u l=0.5u
X283 VDD.t91 a_19500_5863# a_19412_5960# VDD.t90 pfet_05v0 ad=0.5368p pd=3.32u as=0.5368p ps=3.32u w=1.22u l=1u
X284 a_10204_7864# a_10116_7908# VSS VSS nfet_05v0 ad=0.3608p pd=2.52u as=0.3608p ps=2.52u w=0.82u l=1u
X285 a_10204_4728# a_10116_4772# VSS VSS nfet_05v0 ad=0.3608p pd=2.52u as=0.3608p ps=2.52u w=0.82u l=1u
X286 VDD.t708 a_19500_2727# a_19412_2824# VDD.t707 pfet_05v0 ad=0.5368p pd=3.32u as=0.5368p ps=3.32u w=1.22u l=1u
X287 VDD.t331 a_5724_1159# a_5636_1256# VDD.t330 pfet_05v0 ad=0.5368p pd=3.32u as=0.5368p ps=3.32u w=1.22u l=1u
X288 a_15236_15423# a_13924_15047# a_14892_15055# VDD.t1985 pfet_05v0 ad=43.2f pd=0.6u as=0.1872p ps=1.4u w=0.36u l=0.5u
X289 VDD.t968 dac_div_chain\[3\]_inv_notouch_.I dac_div_chain\[3\]_inv_notouch_.ZN VDD.t967 pfet_05v0 ad=0.5368p pd=3.32u as=0.5368p ps=3.32u w=1.22u l=0.5u
X290 a_5276_1159# a_5188_1256# VSS VSS nfet_05v0 ad=0.3608p pd=2.52u as=0.3608p ps=2.52u w=0.82u l=1u
X291 a_1468_1592# a_1380_1636# VSS VSS nfet_05v0 ad=0.3608p pd=2.52u as=0.3608p ps=2.52u w=0.82u l=1u
X292 a_17932_15271# a_17844_15368# VSS VSS nfet_05v0 ad=0.3608p pd=2.52u as=0.3608p ps=2.52u w=0.82u l=1u
X293 a_11996_7864# a_11908_7908# VSS VSS nfet_05v0 ad=0.3608p pd=2.52u as=0.3608p ps=2.52u w=0.82u l=1u
X294 VDD.t1545 a_15244_9432# a_15156_9476# VDD.t1544 pfet_05v0 ad=0.5368p pd=3.32u as=0.5368p ps=3.32u w=1.22u l=1u
X295 VSS a_16612_17316# avo[4].t1 VSS nfet_05v0 ad=0.2132p pd=1.34u as=0.2132p ps=1.34u w=0.82u l=0.6u
X296 ana_div_chain\[0\]_dff_notouch_.D ana_div_chain\[1\]_dff_notouch_.CLK VSS VSS nfet_05v0 ad=0.3608p pd=2.52u as=0.3608p ps=2.52u w=0.82u l=0.6u
X297 a_11996_4728# a_11908_4772# VSS VSS nfet_05v0 ad=0.3608p pd=2.52u as=0.3608p ps=2.52u w=0.82u l=1u
X298 a_7180_4295# a_7092_4392# VSS VSS nfet_05v0 ad=0.3608p pd=2.52u as=0.3608p ps=2.52u w=0.82u l=1u
X299 a_2364_13703# a_2276_13800# VSS VSS nfet_05v0 ad=0.3608p pd=2.52u as=0.3608p ps=2.52u w=0.82u l=1u
X300 VDD.t863 a_3260_6296# a_3172_6340# VDD.t72 pfet_05v0 ad=0.5368p pd=3.32u as=0.5368p ps=3.32u w=1.22u l=1u
X301 VDD.t1032 a_3260_3160# a_3172_3204# VDD.t248 pfet_05v0 ad=0.5368p pd=3.32u as=0.5368p ps=3.32u w=1.22u l=1u
X302 VDD.t1027 a_17260_12135# a_17172_12232# VDD.t1026 pfet_05v0 ad=0.5368p pd=3.32u as=0.5368p ps=3.32u w=1.22u l=1u
X303 VDD.t1146 a_4940_16839# a_4852_16936# VDD.t1145 pfet_05v0 ad=0.5368p pd=3.32u as=0.5368p ps=3.32u w=1.22u l=1u
X304 VDD.t479 a_9756_14136# a_9668_14180# VDD.t478 pfet_05v0 ad=0.5368p pd=3.32u as=0.5368p ps=3.32u w=1.22u l=1u
X305 VDD.t1899 a_10204_7864# a_10116_7908# VDD.t1898 pfet_05v0 ad=0.5368p pd=3.32u as=0.5368p ps=3.32u w=1.22u l=1u
X306 VDD.t1773 a_9756_6296# a_9668_6340# VDD.t1772 pfet_05v0 ad=0.5368p pd=3.32u as=0.5368p ps=3.32u w=1.22u l=1u
X307 VDD.t1216 a_1916_16839# a_1828_16936# VDD.t1215 pfet_05v0 ad=0.5368p pd=3.32u as=0.5368p ps=3.32u w=1.22u l=1u
X308 VDD.t1223 a_9756_3160# a_9668_3204# VDD.t1222 pfet_05v0 ad=0.5368p pd=3.32u as=0.5368p ps=3.32u w=1.22u l=1u
X309 a_11980_11529# ana_div_chain\[2\]_inv_notouch_.ZN a_11856_11161# VDD.t806 pfet_05v0 ad=0.1872p pd=1.4u as=54f ps=0.66u w=0.36u l=0.5u
X310 VDD.t675 a_20060_18407# a_19972_18504# VDD.t674 pfet_05v0 ad=0.5368p pd=3.32u as=0.5368p ps=3.32u w=1.22u l=1u
X311 VSS a_14728_14640# dac_div_chain\[1\]_dff_notouch_.CLK VSS nfet_05v0 ad=0.153p pd=1.195u as=0.2178p ps=1.87u w=0.495u l=0.6u
X312 a_9308_7864# a_9220_7908# VSS VSS nfet_05v0 ad=0.3608p pd=2.52u as=0.3608p ps=2.52u w=0.82u l=1u
X313 a_21964_15271# a_21876_15368# VSS VSS nfet_05v0 ad=0.3608p pd=2.52u as=0.3608p ps=2.52u w=0.82u l=1u
X314 a_9308_4728# a_9220_4772# VSS VSS nfet_05v0 ad=0.3608p pd=2.52u as=0.3608p ps=2.52u w=0.82u l=1u
X315 VDD.t35 a_11996_7864# a_11908_7908# VDD.t34 pfet_05v0 ad=0.5368p pd=3.32u as=0.5368p ps=3.32u w=1.22u l=1u
X316 a_10764_15271# a_10676_15368# VSS VSS nfet_05v0 ad=0.3608p pd=2.52u as=0.3608p ps=2.52u w=0.82u l=1u
X317 a_21964_12135# a_21876_12232# VSS VSS nfet_05v0 ad=0.3608p pd=2.52u as=0.3608p ps=2.52u w=0.82u l=1u
X318 a_9084_1159# a_8996_1256# VSS VSS nfet_05v0 ad=0.3608p pd=2.52u as=0.3608p ps=2.52u w=0.82u l=1u
X319 VDD.t638 a_19948_10567# a_19860_10664# VDD.t637 pfet_05v0 ad=0.5368p pd=3.32u as=0.5368p ps=3.32u w=1.22u l=1u
X320 a_5388_16839# a_5300_16936# VSS VSS nfet_05v0 ad=0.3608p pd=2.52u as=0.3608p ps=2.52u w=0.82u l=1u
X321 a_21516_4295# a_21428_4392# VSS VSS nfet_05v0 ad=0.3608p pd=2.52u as=0.3608p ps=2.52u w=0.82u l=1u
X322 a_8524_15271# a_8436_15368# VSS VSS nfet_05v0 ad=0.3608p pd=2.52u as=0.3608p ps=2.52u w=0.82u l=1u
X323 VDD.t624 a_19388_14136# a_19300_14180# VDD.t623 pfet_05v0 ad=0.5368p pd=3.32u as=0.5368p ps=3.32u w=1.22u l=1u
X324 VDD.t1114 a_14572_16839# a_14484_16936# VDD.t1113 pfet_05v0 ad=0.5368p pd=3.32u as=0.5368p ps=3.32u w=1.22u l=1u
X325 VDD.t548 a_19388_11000# a_19300_11044# VDD.t547 pfet_05v0 ad=0.5368p pd=3.32u as=0.5368p ps=3.32u w=1.22u l=1u
X326 VDD.t103 a_1916_5863# a_1828_5960# VDD.t102 pfet_05v0 ad=0.5368p pd=3.32u as=0.5368p ps=3.32u w=1.22u l=1u
X327 a_10316_8999# a_10228_9096# VSS VSS nfet_05v0 ad=0.3608p pd=2.52u as=0.3608p ps=2.52u w=0.82u l=1u
X328 VSS ana_div_chain\[4\]_dff_notouch_.CLK a_15940_16615# VSS nfet_05v0 ad=0.1053p pd=0.925u as=0.1782p ps=1.69u w=0.405u l=0.6u
X329 a_13168_16189# a_12875_15865# VSS VSS nfet_05v0 ad=0.176p pd=1.68u as=0.142p ps=1.14u w=0.4u l=0.6u
X330 VDD.t424 a_1916_2727# a_1828_2824# VDD.t423 pfet_05v0 ad=0.5368p pd=3.32u as=0.5368p ps=3.32u w=1.22u l=1u
X331 a_10316_5863# a_10228_5960# VSS VSS nfet_05v0 ad=0.3608p pd=2.52u as=0.3608p ps=2.52u w=0.82u l=1u
X332 a_18940_17272# a_18852_17316# VSS VSS nfet_05v0 ad=0.3608p pd=2.52u as=0.3608p ps=2.52u w=0.82u l=1u
X333 VDD.t1909 a_21964_7431# a_21876_7528# VDD.t1908 pfet_05v0 ad=0.5368p pd=3.32u as=0.5368p ps=3.32u w=1.22u l=1u
X334 a_5948_1592# a_5860_1636# VSS VSS nfet_05v0 ad=0.3608p pd=2.52u as=0.3608p ps=2.52u w=0.82u l=1u
X335 a_1468_14136# a_1380_14180# VSS VSS nfet_05v0 ad=0.3608p pd=2.52u as=0.3608p ps=2.52u w=0.82u l=1u
X336 VDD.t1532 a_9104_11875# a_9076_12287# VDD.t1531 pfet_05v0 ad=0.1044p pd=0.94u as=43.2f ps=0.6u w=0.36u l=0.5u
X337 a_1468_11000# a_1380_11044# VSS VSS nfet_05v0 ad=0.3608p pd=2.52u as=0.3608p ps=2.52u w=0.82u l=1u
X338 VSS input1.Z a_18628_13096# VSS nfet_05v0 ad=0.1053p pd=0.925u as=0.1782p ps=1.69u w=0.405u l=0.6u
X339 VDD.t1034 a_9308_7864# a_9220_7908# VDD.t1033 pfet_05v0 ad=0.5368p pd=3.32u as=0.5368p ps=3.32u w=1.22u l=1u
X340 VDD.t1934 a_4156_12568# a_4068_12612# VDD.t661 pfet_05v0 ad=0.5368p pd=3.32u as=0.5368p ps=3.32u w=1.22u l=1u
X341 VDD.t974 a_5948_17272# a_5860_17316# VDD.t973 pfet_05v0 ad=0.5368p pd=3.32u as=0.5368p ps=3.32u w=1.22u l=1u
X342 a_2812_9432# a_2724_9476# VSS VSS nfet_05v0 ad=0.3608p pd=2.52u as=0.3608p ps=2.52u w=0.82u l=1u
X343 a_17596_3160# a_17508_3204# VSS VSS nfet_05v0 ad=0.3608p pd=2.52u as=0.3608p ps=2.52u w=0.82u l=1u
X344 a_6732_8999# a_6644_9096# VSS VSS nfet_05v0 ad=0.3608p pd=2.52u as=0.3608p ps=2.52u w=0.82u l=1u
X345 a_2812_6296# a_2724_6340# VSS VSS nfet_05v0 ad=0.3608p pd=2.52u as=0.3608p ps=2.52u w=0.82u l=1u
X346 VDD.t2086 a_10032_11875# a_10024_12287# VDD.t2085 pfet_05v0 ad=0.23p pd=1.54u as=50.4f ps=0.64u w=0.36u l=0.5u
X347 VDD.t576 a_4604_14136# a_4516_14180# VDD.t575 pfet_05v0 ad=0.5368p pd=3.32u as=0.5368p ps=3.32u w=1.22u l=1u
X348 a_1916_12568# a_1828_12612# VSS VSS nfet_05v0 ad=0.3608p pd=2.52u as=0.3608p ps=2.52u w=0.82u l=1u
X349 a_6732_5863# a_6644_5960# VSS VSS nfet_05v0 ad=0.3608p pd=2.52u as=0.3608p ps=2.52u w=0.82u l=1u
X350 a_18156_12135# a_18068_12232# VSS VSS nfet_05v0 ad=0.3608p pd=2.52u as=0.3608p ps=2.52u w=0.82u l=1u
X351 VDD.t795 a_7740_6296# a_7652_6340# VDD.t794 pfet_05v0 ad=0.5368p pd=3.32u as=0.5368p ps=3.32u w=1.22u l=1u
X352 VDD.t2064 a_4604_11000# a_4516_11044# VDD.t2063 pfet_05v0 ad=0.5368p pd=3.32u as=0.5368p ps=3.32u w=1.22u l=1u
X353 VDD.t1848 a_1020_15271# a_932_15368# VDD.t1716 pfet_05v0 ad=0.5368p pd=3.32u as=0.5368p ps=3.32u w=1.22u l=1u
X354 VDD.t1914 a_7740_3160# a_7652_3204# VDD.t1913 pfet_05v0 ad=0.5368p pd=3.32u as=0.5368p ps=3.32u w=1.22u l=1u
X355 a_22076_9432# a_21988_9476# VSS VSS nfet_05v0 ad=0.3608p pd=2.52u as=0.3608p ps=2.52u w=0.82u l=1u
X356 VDD.t111 a_4940_4295# a_4852_4392# VDD.t110 pfet_05v0 ad=0.5368p pd=3.32u as=0.5368p ps=3.32u w=1.22u l=1u
X357 a_22076_6296# a_21988_6340# VSS VSS nfet_05v0 ad=0.3608p pd=2.52u as=0.3608p ps=2.52u w=0.82u l=1u
X358 VDD.t1783 a_18156_5863# a_18068_5960# VDD.t1782 pfet_05v0 ad=0.5368p pd=3.32u as=0.5368p ps=3.32u w=1.22u l=1u
X359 VDD.t837 a_20732_9432# a_20644_9476# VDD.t836 pfet_05v0 ad=0.5368p pd=3.32u as=0.5368p ps=3.32u w=1.22u l=1u
X360 a_3260_16839# a_3172_16936# VSS VSS nfet_05v0 ad=0.3608p pd=2.52u as=0.3608p ps=2.52u w=0.82u l=1u
X361 a_14892_15055# ana_div_chain\[3\]_inv_notouch_.ZN a_14768_15423# VDD.t611 pfet_05v0 ad=0.1872p pd=1.4u as=54f ps=0.66u w=0.36u l=0.5u
X362 VDD.t736 a_18156_2727# a_18068_2824# VDD.t735 pfet_05v0 ad=0.5368p pd=3.32u as=0.5368p ps=3.32u w=1.22u l=1u
X363 a_21068_7431# a_20980_7528# VSS VSS nfet_05v0 ad=0.3608p pd=2.52u as=0.3608p ps=2.52u w=0.82u l=1u
X364 VDD.t434 a_13876_13639# a_13272_13352# VDD.t433 pfet_05v0 ad=0.23p pd=1.54u as=0.352p ps=2.48u w=0.8u l=0.5u
X365 VDD.t1204 a_20620_16839# a_20532_16936# VDD.t1203 pfet_05v0 ad=0.5368p pd=3.32u as=0.5368p ps=3.32u w=1.22u l=1u
X366 a_13116_14136# a_13028_14180# VSS VSS nfet_05v0 ad=0.3608p pd=2.52u as=0.3608p ps=2.52u w=0.82u l=1u
X367 a_2140_18407# a_2052_18504# VSS VSS nfet_05v0 ad=0.3608p pd=2.52u as=0.3608p ps=2.52u w=0.82u l=1u
X368 VDD.t1713 a_1916_15704# a_1828_15748# VDD.t965 pfet_05v0 ad=0.5368p pd=3.32u as=0.5368p ps=3.32u w=1.22u l=1u
X369 VDD.t1654 a_4044_18407# a_3956_18504# VDD.t1653 pfet_05v0 ad=0.5368p pd=3.32u as=0.5368p ps=3.32u w=1.22u l=1u
X370 a_8972_15271# a_8884_15368# VSS VSS nfet_05v0 ad=0.3608p pd=2.52u as=0.3608p ps=2.52u w=0.82u l=1u
X371 VDD.t495 input1.Z a_18628_13096# VDD.t494 pfet_05v0 ad=0.2249p pd=1.385u as=0.3806p ps=2.61u w=0.865u l=0.5u
X372 VDD.t322 a_7628_4295# a_7540_4392# VDD.t321 pfet_05v0 ad=0.5368p pd=3.32u as=0.5368p ps=3.32u w=1.22u l=1u
X373 VDD.t1886 a_8902_13040# dvo[2].t1 VDD.t1885 pfet_05v0 ad=0.4941p pd=2.03u as=0.3782p ps=1.84u w=1.22u l=0.5u
X374 a_21068_16839# a_20980_16936# VSS VSS nfet_05v0 ad=0.3608p pd=2.52u as=0.3608p ps=2.52u w=0.82u l=1u
X375 a_1468_10567# a_1380_10664# VSS VSS nfet_05v0 ad=0.3608p pd=2.52u as=0.3608p ps=2.52u w=0.82u l=1u
X376 VDD.t903 a_17148_9432# a_17060_9476# VDD.t902 pfet_05v0 ad=0.5368p pd=3.32u as=0.5368p ps=3.32u w=1.22u l=1u
X377 VSS a_14708_12612# dvo[1].t1 VSS nfet_05v0 ad=0.2132p pd=1.34u as=0.2132p ps=1.34u w=0.82u l=0.6u
X378 a_12240_16189# a_11868_16233# VDD.t1492 VDD.t1491 pfet_05v0 ad=0.1791p pd=1.355u as=0.1044p ps=0.94u w=0.36u l=0.5u
X379 VDD.t1277 a_10336_13443# a_10308_13855# VDD.t1276 pfet_05v0 ad=0.1044p pd=0.94u as=43.2f ps=0.6u w=0.36u l=0.5u
X380 a_15580_3160# a_15492_3204# VSS VSS nfet_05v0 ad=0.3608p pd=2.52u as=0.3608p ps=2.52u w=0.82u l=1u
X381 VDD.t1874 a_10876_18407# a_10788_18504# VDD.t1873 pfet_05v0 ad=0.5368p pd=3.32u as=0.5368p ps=3.32u w=1.22u l=1u
X382 a_10652_7864# a_10564_7908# VSS VSS nfet_05v0 ad=0.3608p pd=2.52u as=0.3608p ps=2.52u w=0.82u l=1u
X383 a_4156_8999# a_4068_9096# VSS VSS nfet_05v0 ad=0.3608p pd=2.52u as=0.3608p ps=2.52u w=0.82u l=1u
X384 a_10652_4728# a_10564_4772# VSS VSS nfet_05v0 ad=0.3608p pd=2.52u as=0.3608p ps=2.52u w=0.82u l=1u
X385 a_2812_2727# a_2724_2824# VSS VSS nfet_05v0 ad=0.3608p pd=2.52u as=0.3608p ps=2.52u w=0.82u l=1u
X386 VDD.t867 a_1916_4728# a_1828_4772# VDD.t866 pfet_05v0 ad=0.5368p pd=3.32u as=0.5368p ps=3.32u w=1.22u l=1u
X387 a_4156_5863# a_4068_5960# VSS VSS nfet_05v0 ad=0.3608p pd=2.52u as=0.3608p ps=2.52u w=0.82u l=1u
X388 VDD.t1 a_1916_1592# a_1828_1636# VDD.t0 pfet_05v0 ad=0.5368p pd=3.32u as=0.5368p ps=3.32u w=1.22u l=1u
X389 a_19940_12729# a_18628_13096# a_19596_13097# VDD.t531 pfet_05v0 ad=43.2f pd=0.6u as=0.1872p ps=1.4u w=0.36u l=0.5u
X390 a_2364_17272# a_2276_17316# VSS VSS nfet_05v0 ad=0.3608p pd=2.52u as=0.3608p ps=2.52u w=0.82u l=1u
X391 VDD.t314 a_16364_7431# a_16276_7528# VDD.t313 pfet_05v0 ad=0.5368p pd=3.32u as=0.5368p ps=3.32u w=1.22u l=1u
X392 VDD.t1543 a_15692_9432# a_15604_9476# VDD.t1542 pfet_05v0 ad=0.5368p pd=3.32u as=0.5368p ps=3.32u w=1.22u l=1u
X393 VDD.t1330 a_21628_17272# a_21540_17316# VDD.t1329 pfet_05v0 ad=0.5368p pd=3.32u as=0.5368p ps=3.32u w=1.22u l=1u
X394 VDD.t1319 a_9308_15704# a_9220_15748# VDD.t1318 pfet_05v0 ad=0.5368p pd=3.32u as=0.5368p ps=3.32u w=1.22u l=1u
X395 VSS a_12192_13053# a_12152_12637# VSS nfet_05v0 ad=0.1053p pd=0.925u as=0.1782p ps=1.69u w=0.405u l=0.6u
X396 VDD.t105 a_2364_4295# a_2276_4392# VDD.t104 pfet_05v0 ad=0.5368p pd=3.32u as=0.5368p ps=3.32u w=1.22u l=1u
X397 VDD.t856 a_13788_6296# a_13700_6340# VDD.t855 pfet_05v0 ad=0.5368p pd=3.32u as=0.5368p ps=3.32u w=1.22u l=1u
X398 VDD.t749 a_2364_1159# a_2276_1256# VDD.t255 pfet_05v0 ad=0.5368p pd=3.32u as=0.5368p ps=3.32u w=1.22u l=1u
X399 VDD.t1182 a_13788_3160# a_13700_3204# VDD.t1181 pfet_05v0 ad=0.5368p pd=3.32u as=0.5368p ps=3.32u w=1.22u l=1u
X400 avo[3].t4 a_11478_11784# VSS VSS nfet_05v0 ad=0.2132p pd=1.34u as=0.2132p ps=1.34u w=0.82u l=0.6u
X401 VSS a_17862_17744# avo[5].t0 VSS nfet_05v0 ad=0.2132p pd=1.34u as=0.3608p ps=2.52u w=0.82u l=0.6u
X402 a_2812_15704# a_2724_15748# VSS VSS nfet_05v0 ad=0.3608p pd=2.52u as=0.3608p ps=2.52u w=0.82u l=1u
X403 VSS a_17565_808# a_17685_852# VSS nfet_05v0 ad=93.59999f pd=0.88u as=43.2f ps=0.6u w=0.36u l=0.6u
X404 VDD.t901 a_5836_8999# a_5748_9096# VDD.t900 pfet_05v0 ad=0.5368p pd=3.32u as=0.5368p ps=3.32u w=1.22u l=1u
X405 VDD.t544 a_18940_9432# a_18852_9476# VDD.t543 pfet_05v0 ad=0.5368p pd=3.32u as=0.5368p ps=3.32u w=1.22u l=1u
X406 a_18200_16991# a_16352_16936# a_17915_16991# VDD.t1712 pfet_05v0 ad=50.4f pd=0.64u as=0.1665p ps=1.285u w=0.36u l=0.5u
X407 a_3260_7864# a_3172_7908# VSS VSS nfet_05v0 ad=0.3608p pd=2.52u as=0.3608p ps=2.52u w=0.82u l=1u
X408 a_12352_11485# a_11980_11529# VDD.t446 VDD.t445 pfet_05v0 ad=0.1791p pd=1.355u as=0.1044p ps=0.94u w=0.36u l=0.5u
X409 VDD.t2094 a_10652_7864# a_10564_7908# VDD.t2093 pfet_05v0 ad=0.5368p pd=3.32u as=0.5368p ps=3.32u w=1.22u l=1u
X410 a_19500_16839# a_19412_16936# VSS VSS nfet_05v0 ad=0.3608p pd=2.52u as=0.3608p ps=2.52u w=0.82u l=1u
X411 a_3260_4728# a_3172_4772# VSS VSS nfet_05v0 ad=0.3608p pd=2.52u as=0.3608p ps=2.52u w=0.82u l=1u
X412 dvo[4].t3 a_10788_17316# VDD.t1157 VDD.t1156 pfet_05v0 ad=0.3782p pd=1.84u as=0.4941p ps=2.03u w=1.22u l=0.5u
X413 VDD.t1371 a_14320_13443# a_14280_13811# VDD.t1370 pfet_05v0 ad=0.2249p pd=1.385u as=0.3806p ps=2.61u w=0.865u l=0.5u
X414 a_4156_1159# a_4068_1256# VSS VSS nfet_05v0 ad=0.3608p pd=2.52u as=0.3608p ps=2.52u w=0.82u l=1u
X415 a_19052_2727# a_18964_2824# VSS VSS nfet_05v0 ad=0.3608p pd=2.52u as=0.3608p ps=2.52u w=0.82u l=1u
X416 a_8188_15704# a_8100_15748# VSS VSS nfet_05v0 ad=0.3608p pd=2.52u as=0.3608p ps=2.52u w=0.82u l=1u
X417 a_9756_7864# a_9668_7908# VSS VSS nfet_05v0 ad=0.3608p pd=2.52u as=0.3608p ps=2.52u w=0.82u l=1u
X418 a_1468_9432# a_1380_9476# VSS VSS nfet_05v0 ad=0.3608p pd=2.52u as=0.3608p ps=2.52u w=0.82u l=1u
X419 a_17862_17744# ana_div_chain\[4\]_dff_notouch_.Q VSS VSS nfet_05v0 ad=0.3608p pd=2.52u as=0.2911p ps=1.53u w=0.82u l=0.6u
X420 a_9756_4728# a_9668_4772# VSS VSS nfet_05v0 ad=0.3608p pd=2.52u as=0.3608p ps=2.52u w=0.82u l=1u
X421 a_1468_6296# a_1380_6340# VSS VSS nfet_05v0 ad=0.3608p pd=2.52u as=0.3608p ps=2.52u w=0.82u l=1u
X422 a_5388_8999# a_5300_9096# VSS VSS nfet_05v0 ad=0.3608p pd=2.52u as=0.3608p ps=2.52u w=0.82u l=1u
X423 a_21180_1592# a_21092_1636# VSS VSS nfet_05v0 ad=0.3608p pd=2.52u as=0.3608p ps=2.52u w=0.82u l=1u
X424 a_5388_5863# a_5300_5960# VSS VSS nfet_05v0 ad=0.3608p pd=2.52u as=0.3608p ps=2.52u w=0.82u l=1u
X425 VDD.t378 a_6396_6296# a_6308_6340# VDD.t377 pfet_05v0 ad=0.5368p pd=3.32u as=0.5368p ps=3.32u w=1.22u l=1u
X426 VDD.t477 a_16700_14136# a_16612_14180# VDD.t476 pfet_05v0 ad=0.5368p pd=3.32u as=0.5368p ps=3.32u w=1.22u l=1u
X427 a_14012_17272# a_13924_17316# VSS VSS nfet_05v0 ad=0.3608p pd=2.52u as=0.3608p ps=2.52u w=0.82u l=1u
X428 VDD.t1549 a_6396_3160# a_6308_3204# VDD.t1548 pfet_05v0 ad=0.5368p pd=3.32u as=0.5368p ps=3.32u w=1.22u l=1u
X429 VDD.t919 a_16700_11000# a_16612_11044# VDD.t918 pfet_05v0 ad=0.5368p pd=3.32u as=0.5368p ps=3.32u w=1.22u l=1u
X430 a_21964_4295# a_21876_4392# VSS VSS nfet_05v0 ad=0.3608p pd=2.52u as=0.3608p ps=2.52u w=0.82u l=1u
X431 VSS a_11366_10216# avo[2].t4 VSS nfet_05v0 ad=0.2911p pd=1.53u as=0.2132p ps=1.34u w=0.82u l=0.6u
X432 VSS a_13988_12071# a_13384_11784# VSS nfet_05v0 ad=0.142p pd=1.14u as=0.176p ps=1.68u w=0.4u l=0.6u
X433 VDD.t1812 a_17565_808# a_17685_1428# VDD.t1811 pfet_05v0 ad=0.1116p pd=0.98u as=61.19999f ps=0.7u w=0.36u l=0.5u
X434 VDD.t1929 a_20620_7431# a_20532_7528# VDD.t1928 pfet_05v0 ad=0.5368p pd=3.32u as=0.5368p ps=3.32u w=1.22u l=1u
X435 a_4604_1592# a_4516_1636# VSS VSS nfet_05v0 ad=0.3608p pd=2.52u as=0.3608p ps=2.52u w=0.82u l=1u
X436 VDD.t414 a_10428_1159# a_10340_1256# VDD.t413 pfet_05v0 ad=0.5368p pd=3.32u as=0.5368p ps=3.32u w=1.22u l=1u
X437 a_17708_10567# a_17620_10664# VSS VSS nfet_05v0 ad=0.3608p pd=2.52u as=0.3608p ps=2.52u w=0.82u l=1u
X438 avo[3].t0 a_11478_11784# VDD.t2082 VDD.t2081 pfet_05v0 ad=0.3782p pd=1.84u as=0.3782p ps=1.84u w=1.22u l=0.5u
X439 a_8076_16839# a_7988_16936# VSS VSS nfet_05v0 ad=0.3608p pd=2.52u as=0.3608p ps=2.52u w=0.82u l=1u
X440 a_10764_8999# a_10676_9096# VSS VSS nfet_05v0 ad=0.3608p pd=2.52u as=0.3608p ps=2.52u w=0.82u l=1u
X441 VDD.t1733 a_3260_7864# a_3172_7908# VDD.t268 pfet_05v0 ad=0.5368p pd=3.32u as=0.5368p ps=3.32u w=1.22u l=1u
X442 a_10764_5863# a_10676_5960# VSS VSS nfet_05v0 ad=0.3608p pd=2.52u as=0.3608p ps=2.52u w=0.82u l=1u
X443 a_3708_7431# a_3620_7528# VSS VSS nfet_05v0 ad=0.3608p pd=2.52u as=0.3608p ps=2.52u w=0.82u l=1u
X444 VDD.t1665 a_5836_10567# a_5748_10664# VDD.t1664 pfet_05v0 ad=0.5368p pd=3.32u as=0.5368p ps=3.32u w=1.22u l=1u
X445 VDD.t1317 a_9756_15704# a_9668_15748# VDD.t1316 pfet_05v0 ad=0.5368p pd=3.32u as=0.5368p ps=3.32u w=1.22u l=1u
X446 VDD.t789 a_9756_7864# a_9668_7908# VDD.t788 pfet_05v0 ad=0.5368p pd=3.32u as=0.5368p ps=3.32u w=1.22u l=1u
X447 VDD.t970 dac_div_chain\[3\]_inv_notouch_.I a_10788_17316# VDD.t969 pfet_05v0 ad=0.4941p pd=2.03u as=0.5368p ps=3.32u w=1.22u l=0.5u
X448 a_12875_15865# a_10900_16232# a_12240_16189# VDD.t1054 pfet_05v0 ad=0.1665p pd=1.285u as=0.1791p ps=1.355u w=0.36u l=0.5u
X449 a_4156_14136# a_4068_14180# VSS VSS nfet_05v0 ad=0.3608p pd=2.52u as=0.3608p ps=2.52u w=0.82u l=1u
X450 a_9104_11875# a_8732_11919# VSS VSS nfet_05v0 ad=93.59999f pd=0.88u as=0.2637p ps=1.825u w=0.36u l=0.6u
X451 VDD.t1946 a_19388_4728# a_19300_4772# VDD.t1945 pfet_05v0 ad=0.5368p pd=3.32u as=0.5368p ps=3.32u w=1.22u l=1u
X452 a_17260_7431# a_17172_7528# VSS VSS nfet_05v0 ad=0.3608p pd=2.52u as=0.3608p ps=2.52u w=0.82u l=1u
X453 a_4156_11000# a_4068_11044# VSS VSS nfet_05v0 ad=0.3608p pd=2.52u as=0.3608p ps=2.52u w=0.82u l=1u
X454 VDD.t1857 a_20732_11000# a_20644_11044# VDD.t1856 pfet_05v0 ad=0.5368p pd=3.32u as=0.5368p ps=3.32u w=1.22u l=1u
X455 VDD.t1254 a_19388_1592# a_19300_1636# VDD.t1253 pfet_05v0 ad=0.5368p pd=3.32u as=0.5368p ps=3.32u w=1.22u l=1u
X456 avo[5].t1 a_17862_17744# VSS VSS nfet_05v0 ad=0.2132p pd=1.34u as=0.2132p ps=1.34u w=0.82u l=0.6u
X457 a_7740_7864# a_7652_7908# VSS VSS nfet_05v0 ad=0.3608p pd=2.52u as=0.3608p ps=2.52u w=0.82u l=1u
X458 a_4604_12568# a_4516_12612# VSS VSS nfet_05v0 ad=0.3608p pd=2.52u as=0.3608p ps=2.52u w=0.82u l=1u
X459 a_13788_18407# a_13700_18504# VSS VSS nfet_05v0 ad=0.3608p pd=2.52u as=0.3608p ps=2.52u w=0.82u l=1u
X460 a_7740_4728# a_7652_4772# VSS VSS nfet_05v0 ad=0.3608p pd=2.52u as=0.3608p ps=2.52u w=0.82u l=1u
X461 a_9796_13487# a_8996_13479# VSS VSS nfet_05v0 ad=43.2f pd=0.6u as=0.1584p ps=1.6u w=0.36u l=0.6u
X462 VDD.t1309 a_15468_10567# a_15380_10664# VDD.t1289 pfet_05v0 ad=0.5368p pd=3.32u as=0.5368p ps=3.32u w=1.22u l=1u
X463 VSS a_8008_11504# dac_div_chain\[2\]_load_slew15.Z VSS nfet_05v0 ad=0.153p pd=1.195u as=0.2178p ps=1.87u w=0.495u l=0.6u
X464 dvo[4].t5 a_10788_17316# VDD.t1161 VDD.t1160 pfet_05v0 ad=0.5368p pd=3.32u as=0.3782p ps=1.84u w=1.22u l=0.5u
X465 a_1468_2727# a_1380_2824# VSS VSS nfet_05v0 ad=0.3608p pd=2.52u as=0.3608p ps=2.52u w=0.82u l=1u
X466 a_5948_9432# a_5860_9476# VSS VSS nfet_05v0 ad=0.3608p pd=2.52u as=0.3608p ps=2.52u w=0.82u l=1u
X467 VSS dac_div_chain\[1\]_inv_notouch_.I dac_div_chain\[1\]_inv_notouch_.ZN VSS nfet_05v0 ad=0.3608p pd=2.52u as=0.3608p ps=2.52u w=0.82u l=0.6u
X468 a_5948_6296# a_5860_6340# VSS VSS nfet_05v0 ad=0.3608p pd=2.52u as=0.3608p ps=2.52u w=0.82u l=1u
X469 a_9868_8999# a_9780_9096# VSS VSS nfet_05v0 ad=0.3608p pd=2.52u as=0.3608p ps=2.52u w=0.82u l=1u
X470 ana_div_chain\[3\]_inv_notouch_.I a_16192_15011# VSS VSS nfet_05v0 ad=0.2132p pd=1.34u as=0.3608p ps=2.52u w=0.82u l=0.6u
X471 a_9868_5863# a_9780_5960# VSS VSS nfet_05v0 ad=0.3608p pd=2.52u as=0.3608p ps=2.52u w=0.82u l=1u
X472 VDD.t57 a_21068_5863# a_20980_5960# VDD.t56 pfet_05v0 ad=0.5368p pd=3.32u as=0.5368p ps=3.32u w=1.22u l=1u
X473 VDD.t300 a_21068_2727# a_20980_2824# VDD.t299 pfet_05v0 ad=0.5368p pd=3.32u as=0.5368p ps=3.32u w=1.22u l=1u
X474 a_14460_17272# a_14372_17316# VSS VSS nfet_05v0 ad=0.3608p pd=2.52u as=0.3608p ps=2.52u w=0.82u l=1u
X475 VDD.t1120 a_6284_15271# a_6196_15368# VDD.t1119 pfet_05v0 ad=0.5368p pd=3.32u as=0.5368p ps=3.32u w=1.22u l=1u
X476 a_12987_11161# a_11012_11528# a_12352_11485# VDD.t1017 pfet_05v0 ad=0.1665p pd=1.285u as=0.1791p ps=1.355u w=0.36u l=0.5u
X477 VDD.t1386 a_1468_17272# a_1380_17316# VDD.t1217 pfet_05v0 ad=0.5368p pd=3.32u as=0.5368p ps=3.32u w=1.22u l=1u
X478 a_11256_16533# dvo[4].t7 VDD.t245 VDD.t244 pfet_05v0 ad=0.462p pd=2.98u as=0.4015p ps=1.92u w=1.05u l=0.5u
X479 a_17061_852# a_16941_808# VSS VSS nfet_05v0 ad=43.8f pd=0.605u as=0.28262p ps=1.87u w=0.365u l=0.6u
X480 VDD.t679 a_4604_15704# a_4516_15748# VDD.t678 pfet_05v0 ad=0.5368p pd=3.32u as=0.5368p ps=3.32u w=1.22u l=1u
X481 VDD.t1227 a_7740_7864# a_7652_7908# VDD.t1226 pfet_05v0 ad=0.5368p pd=3.32u as=0.5368p ps=3.32u w=1.22u l=1u
X482 VDD.t281 a_17596_9432# a_17508_9476# VDD.t280 pfet_05v0 ad=0.5368p pd=3.32u as=0.5368p ps=3.32u w=1.22u l=1u
X483 a_4828_1159# a_4740_1256# VSS VSS nfet_05v0 ad=0.3608p pd=2.52u as=0.3608p ps=2.52u w=0.82u l=1u
X484 a_12444_1159# a_12356_1256# VSS VSS nfet_05v0 ad=0.3608p pd=2.52u as=0.3608p ps=2.52u w=0.82u l=1u
X485 a_16364_4295# a_16276_4392# VSS VSS nfet_05v0 ad=0.3608p pd=2.52u as=0.3608p ps=2.52u w=0.82u l=1u
X486 VDD.t183 a_15020_7431# a_14932_7528# VDD.t182 pfet_05v0 ad=0.5368p pd=3.32u as=0.5368p ps=3.32u w=1.22u l=1u
X487 a_7180_10567# a_7092_10664# VSS VSS nfet_05v0 ad=0.3608p pd=2.52u as=0.3608p ps=2.52u w=0.82u l=1u
X488 VDD.t263 a_1020_4295# a_932_4392# VDD.t202 pfet_05v0 ad=0.5368p pd=3.32u as=0.5368p ps=3.32u w=1.22u l=1u
X489 a_4156_10567# a_4068_10664# VSS VSS nfet_05v0 ad=0.3608p pd=2.52u as=0.3608p ps=2.52u w=0.82u l=1u
X490 VDD.t65 a_12444_6296# a_12356_6340# VDD.t64 pfet_05v0 ad=0.5368p pd=3.32u as=0.5368p ps=3.32u w=1.22u l=1u
X491 VDD.t285 a_1020_1159# a_932_1256# VDD.t284 pfet_05v0 ad=0.5368p pd=3.32u as=0.5368p ps=3.32u w=1.22u l=1u
X492 a_9984_11919# a_7764_11911# a_9739_12287# VSS nfet_05v0 ad=43.2f pd=0.6u as=93.59999f ps=0.88u w=0.36u l=0.6u
X493 VDD.t1192 a_12444_3160# a_12356_3204# VDD.t1191 pfet_05v0 ad=0.5368p pd=3.32u as=0.5368p ps=3.32u w=1.22u l=1u
X494 VDD.t1680 a_21516_10567# a_21428_10664# VDD.t1679 pfet_05v0 ad=0.5368p pd=3.32u as=0.5368p ps=3.32u w=1.22u l=1u
X495 VDD.t1275 a_7292_12568# a_7204_12612# VDD.t1274 pfet_05v0 ad=0.5368p pd=3.32u as=0.5368p ps=3.32u w=1.22u l=1u
X496 VDD.t1498 a_6732_13703# a_6644_13800# VDD.t1497 pfet_05v0 ad=0.5368p pd=3.32u as=0.5368p ps=3.32u w=1.22u l=1u
X497 dac_div_chain\[1\]_inv_notouch_.I a_11144_12971# VDD.t1506 VDD.t1505 pfet_05v0 ad=0.3172p pd=1.74u as=0.854p ps=3.84u w=1.22u l=0.5u
X498 VDD.t907 ana_div_chain\[2\]_dff_notouch_.Q a_13924_15047# VDD.t906 pfet_05v0 ad=0.2249p pd=1.385u as=0.3806p ps=2.61u w=0.865u l=0.5u
X499 VDD.t947 a_10316_10567# a_10228_10664# VDD.t946 pfet_05v0 ad=0.5368p pd=3.32u as=0.5368p ps=3.32u w=1.22u l=1u
X500 a_1916_3160# a_1828_3204# VSS VSS nfet_05v0 ad=0.3608p pd=2.52u as=0.3608p ps=2.52u w=0.82u l=1u
X501 a_9420_18407# a_9332_18504# VSS VSS nfet_05v0 ad=0.3608p pd=2.52u as=0.3608p ps=2.52u w=0.82u l=1u
X502 VDD.t598 a_3708_13703# a_3620_13800# VDD.t597 pfet_05v0 ad=0.5368p pd=3.32u as=0.5368p ps=3.32u w=1.22u l=1u
X503 VDD.t333 a_7516_1159# a_7428_1256# VDD.t332 pfet_05v0 ad=0.5368p pd=3.32u as=0.5368p ps=3.32u w=1.22u l=1u
X504 VDD.t1013 a_8963_18100# uio_oe[1].t0 VDD.t1012 pfet_05v0 ad=0.5368p pd=3.32u as=0.5368p ps=3.32u w=1.22u l=0.5u
X505 VDD.t352 a_7740_14136# a_7652_14180# VDD.t351 pfet_05v0 ad=0.5368p pd=3.32u as=0.5368p ps=3.32u w=1.22u l=1u
X506 a_5052_17272# a_4964_17316# VSS VSS nfet_05v0 ad=0.3608p pd=2.52u as=0.3608p ps=2.52u w=0.82u l=1u
X507 VDD.t1956 a_8860_6296# a_8772_6340# VDD.t1955 pfet_05v0 ad=0.5368p pd=3.32u as=0.5368p ps=3.32u w=1.22u l=1u
X508 a_13788_7864# a_13700_7908# VSS VSS nfet_05v0 ad=0.3608p pd=2.52u as=0.3608p ps=2.52u w=0.82u l=1u
X509 VDD.t1104 a_13116_17272# a_13028_17316# VDD.t1103 pfet_05v0 ad=0.5368p pd=3.32u as=0.5368p ps=3.32u w=1.22u l=1u
X510 VDD.t1484 a_8860_3160# a_8772_3204# VDD.t1483 pfet_05v0 ad=0.5368p pd=3.32u as=0.5368p ps=3.32u w=1.22u l=1u
X511 a_13788_4728# a_13700_4772# VSS VSS nfet_05v0 ad=0.3608p pd=2.52u as=0.3608p ps=2.52u w=0.82u l=1u
X512 a_1468_15271# a_1380_15368# VSS VSS nfet_05v0 ad=0.3608p pd=2.52u as=0.3608p ps=2.52u w=0.82u l=1u
X513 a_5500_15704# a_5412_15748# VSS VSS nfet_05v0 ad=0.3608p pd=2.52u as=0.3608p ps=2.52u w=0.82u l=1u
X514 avo[0].t2 a_20420_14180# VSS VSS nfet_05v0 ad=0.2132p pd=1.34u as=0.2911p ps=1.53u w=0.82u l=0.6u
X515 a_1468_12135# a_1380_12232# VSS VSS nfet_05v0 ad=0.3608p pd=2.52u as=0.3608p ps=2.52u w=0.82u l=1u
X516 VDD.t53 a_5052_6296# a_4964_6340# VDD.t52 pfet_05v0 ad=0.5368p pd=3.32u as=0.5368p ps=3.32u w=1.22u l=1u
X517 a_8636_1159# a_8548_1256# VSS VSS nfet_05v0 ad=0.3608p pd=2.52u as=0.3608p ps=2.52u w=0.82u l=1u
X518 a_4940_13703# a_4852_13800# VSS VSS nfet_05v0 ad=0.3608p pd=2.52u as=0.3608p ps=2.52u w=0.82u l=1u
X519 VDD.t517 a_5052_3160# a_4964_3204# VDD.t516 pfet_05v0 ad=0.5368p pd=3.32u as=0.5368p ps=3.32u w=1.22u l=1u
X520 a_15899_15423# a_13924_15047# a_15264_15011# VDD.t1986 pfet_05v0 ad=0.1665p pd=1.285u as=0.1791p ps=1.355u w=0.36u l=0.5u
X521 a_1916_13703# a_1828_13800# VSS VSS nfet_05v0 ad=0.3608p pd=2.52u as=0.3608p ps=2.52u w=0.82u l=1u
X522 a_20620_4295# a_20532_4392# VSS VSS nfet_05v0 ad=0.3608p pd=2.52u as=0.3608p ps=2.52u w=0.82u l=1u
X523 VDD.t1080 a_21292_15704# a_21204_15748# VDD.t1079 pfet_05v0 ad=0.5368p pd=3.32u as=0.5368p ps=3.32u w=1.22u l=1u
X524 VDD.t1759 avo[3].t6 a_10340_11575# VDD.t1758 pfet_05v0 ad=0.4015p pd=1.92u as=0.462p ps=2.98u w=1.05u l=0.5u
X525 VDD.t1132 a_16812_12135# a_16724_12232# VDD.t1131 pfet_05v0 ad=0.5368p pd=3.32u as=0.5368p ps=3.32u w=1.22u l=1u
X526 a_6396_7864# a_6308_7908# VSS VSS nfet_05v0 ad=0.3608p pd=2.52u as=0.3608p ps=2.52u w=0.82u l=1u
X527 VDD.t205 a_13788_7864# a_13700_7908# VDD.t204 pfet_05v0 ad=0.5368p pd=3.32u as=0.5368p ps=3.32u w=1.22u l=1u
X528 a_6396_4728# a_6308_4772# VSS VSS nfet_05v0 ad=0.3608p pd=2.52u as=0.3608p ps=2.52u w=0.82u l=1u
X529 VDD.t287 a_10876_1159# a_10788_1256# VDD.t286 pfet_05v0 ad=0.5368p pd=3.32u as=0.5368p ps=3.32u w=1.22u l=1u
X530 a_16700_12568# a_16612_12612# VSS VSS nfet_05v0 ad=0.3608p pd=2.52u as=0.3608p ps=2.52u w=0.82u l=1u
X531 VDD.t874 a_19500_7431# a_19412_7528# VDD.t873 pfet_05v0 ad=0.5368p pd=3.32u as=0.5368p ps=3.32u w=1.22u l=1u
X532 a_8732_11919# dac_div_chain\[2\]_dff_notouch_.D a_8564_11919# VSS nfet_05v0 ad=0.207p pd=1.51u as=43.2f ps=0.6u w=0.36u l=0.6u
X533 a_15916_8999# a_15828_9096# VSS VSS nfet_05v0 ad=0.3608p pd=2.52u as=0.3608p ps=2.52u w=0.82u l=1u
X534 a_15916_5863# a_15828_5960# VSS VSS nfet_05v0 ad=0.3608p pd=2.52u as=0.3608p ps=2.52u w=0.82u l=1u
X535 a_13876_13639# a_14280_13811# a_14224_13855# VDD.t1365 pfet_05v0 ad=0.1665p pd=1.285u as=50.4f ps=0.64u w=0.36u l=0.5u
X536 VDD.t2048 a_9868_16839# a_9780_16936# VDD.t2047 pfet_05v0 ad=0.5368p pd=3.32u as=0.5368p ps=3.32u w=1.22u l=1u
X537 VDD.t1678 a_21964_10567# a_21876_10664# VDD.t1677 pfet_05v0 ad=0.5368p pd=3.32u as=0.5368p ps=3.32u w=1.22u l=1u
X538 VDD.t1702 a_17862_17744# avo[5].t5 VDD.t1701 pfet_05v0 ad=0.4941p pd=2.03u as=0.3782p ps=1.84u w=1.22u l=0.5u
X539 VDD.t150 a_18044_4728# a_17956_4772# VDD.t149 pfet_05v0 ad=0.5368p pd=3.32u as=0.5368p ps=3.32u w=1.22u l=1u
X540 VDD.t945 a_10764_10567# a_10676_10664# VDD.t944 pfet_05v0 ad=0.5368p pd=3.32u as=0.5368p ps=3.32u w=1.22u l=1u
X541 VDD.t45 a_18044_1592# a_17956_1636# VDD.t44 pfet_05v0 ad=0.5368p pd=3.32u as=0.5368p ps=3.32u w=1.22u l=1u
X542 VDD.t107 a_3708_5863# a_3620_5960# VDD.t106 pfet_05v0 ad=0.5368p pd=3.32u as=0.5368p ps=3.32u w=1.22u l=1u
X543 a_12108_8999# a_12020_9096# VSS VSS nfet_05v0 ad=0.3608p pd=2.52u as=0.3608p ps=2.52u w=0.82u l=1u
X544 VDD.t519 a_18380_15271# a_18292_15368# VDD.t518 pfet_05v0 ad=0.5368p pd=3.32u as=0.5368p ps=3.32u w=1.22u l=1u
X545 a_15020_16839# a_14932_16936# VSS VSS nfet_05v0 ad=0.3608p pd=2.52u as=0.3608p ps=2.52u w=0.82u l=1u
X546 VDD.t878 a_3708_2727# a_3620_2824# VDD.t782 pfet_05v0 ad=0.5368p pd=3.32u as=0.5368p ps=3.32u w=1.22u l=1u
X547 a_12108_5863# a_12020_5960# VSS VSS nfet_05v0 ad=0.3608p pd=2.52u as=0.3608p ps=2.52u w=0.82u l=1u
X548 VDD.t1838 a_5388_12135# a_5300_12232# VDD.t1837 pfet_05v0 ad=0.5368p pd=3.32u as=0.5368p ps=3.32u w=1.22u l=1u
X549 a_21180_9432# a_21092_9476# VSS VSS nfet_05v0 ad=0.3608p pd=2.52u as=0.3608p ps=2.52u w=0.82u l=1u
X550 a_20284_11000# a_20196_11044# VSS VSS nfet_05v0 ad=0.3608p pd=2.52u as=0.3608p ps=2.52u w=0.82u l=1u
X551 a_21180_6296# a_21092_6340# VSS VSS nfet_05v0 ad=0.3608p pd=2.52u as=0.3608p ps=2.52u w=0.82u l=1u
X552 VDD.t1102 a_13564_17272# a_13476_17316# VDD.t1101 pfet_05v0 ad=0.5368p pd=3.32u as=0.5368p ps=3.32u w=1.22u l=1u
X553 VDD.t372 a_17260_5863# a_17172_5960# VDD.t371 pfet_05v0 ad=0.5368p pd=3.32u as=0.5368p ps=3.32u w=1.22u l=1u
X554 VDD.t604 a_6396_7864# a_6308_7908# VDD.t603 pfet_05v0 ad=0.5368p pd=3.32u as=0.5368p ps=3.32u w=1.22u l=1u
X555 VDD.t1124 a_10316_4295# a_10228_4392# VDD.t1123 pfet_05v0 ad=0.5368p pd=3.32u as=0.5368p ps=3.32u w=1.22u l=1u
X556 VDD.t220 a_16700_15704# a_16612_15748# VDD.t219 pfet_05v0 ad=0.5368p pd=3.32u as=0.5368p ps=3.32u w=1.22u l=1u
X557 VDD.t162 a_17260_2727# a_17172_2824# VDD.t161 pfet_05v0 ad=0.5368p pd=3.32u as=0.5368p ps=3.32u w=1.22u l=1u
X558 a_4604_9432# a_4516_9476# VSS VSS nfet_05v0 ad=0.3608p pd=2.52u as=0.3608p ps=2.52u w=0.82u l=1u
X559 VDD.t1935 a_3708_12568# a_3620_12612# VDD.t663 pfet_05v0 ad=0.5368p pd=3.32u as=0.5368p ps=3.32u w=1.22u l=1u
X560 a_19388_3160# a_19300_3204# VSS VSS nfet_05v0 ad=0.3608p pd=2.52u as=0.3608p ps=2.52u w=0.82u l=1u
X561 a_8524_8999# a_8436_9096# VSS VSS nfet_05v0 ad=0.3608p pd=2.52u as=0.3608p ps=2.52u w=0.82u l=1u
X562 VDD.t420 a_12220_14136# a_12132_14180# VDD.t419 pfet_05v0 ad=0.5368p pd=3.32u as=0.5368p ps=3.32u w=1.22u l=1u
X563 a_4604_6296# a_4516_6340# VSS VSS nfet_05v0 ad=0.3608p pd=2.52u as=0.3608p ps=2.52u w=0.82u l=1u
X564 a_8524_5863# a_8436_5960# VSS VSS nfet_05v0 ad=0.3608p pd=2.52u as=0.3608p ps=2.52u w=0.82u l=1u
X565 VSS ana_div_chain\[2\]_dff_notouch_.CLK a_11012_11528# VSS nfet_05v0 ad=0.1053p pd=0.925u as=0.1782p ps=1.69u w=0.405u l=0.6u
X566 a_17708_12135# a_17620_12232# VSS VSS nfet_05v0 ad=0.3608p pd=2.52u as=0.3608p ps=2.52u w=0.82u l=1u
X567 VDD.t716 a_21709_808# a_21829_1428# VDD.t715 pfet_05v0 ad=0.1116p pd=0.98u as=61.19999f ps=0.7u w=0.36u l=0.5u
X568 ana_div_chain\[3\]_inv_notouch_.I a_16192_15011# VDD.t454 VDD.t453 pfet_05v0 ad=0.3172p pd=1.74u as=0.5368p ps=3.32u w=1.22u l=0.5u
X569 VDD.t79 a_6732_4295# a_6644_4392# VDD.t78 pfet_05v0 ad=0.5368p pd=3.32u as=0.5368p ps=3.32u w=1.22u l=1u
X570 a_13228_10567# a_13140_10664# VSS VSS nfet_05v0 ad=0.3608p pd=2.52u as=0.3608p ps=2.52u w=0.82u l=1u
X571 VDD.t2034 a_18156_10567# a_18068_10664# VDD.t2033 pfet_05v0 ad=0.5368p pd=3.32u as=0.5368p ps=3.32u w=1.22u l=1u
X572 dac_div_chain\[0\]_inv_notouch_.ZN dac_div_chain\[1\]_dff_notouch_.CLK VSS VSS nfet_05v0 ad=0.3608p pd=2.52u as=0.3608p ps=2.52u w=0.82u l=0.6u
X573 a_13508_12729# dac_div_chain\[1\]_inv_notouch_.ZN a_12640_12932# VDD.t208 pfet_05v0 ad=54f pd=0.66u as=0.1872p ps=1.4u w=0.36u l=0.5u
X574 a_12096_12729# a_11144_12971# VDD.t1510 VDD.t1509 pfet_05v0 ad=50.4f pd=0.64u as=0.23p ps=1.54u w=0.36u l=0.5u
X575 a_2812_16839# a_2724_16936# VSS VSS nfet_05v0 ad=0.3608p pd=2.52u as=0.3608p ps=2.52u w=0.82u l=1u
X576 a_17915_16991# a_16352_16936# a_17280_16579# VSS nfet_05v0 ad=93.59999f pd=0.88u as=93.59999f ps=0.88u w=0.36u l=0.6u
X577 a_15020_4295# a_14932_4392# VSS VSS nfet_05v0 ad=0.3608p pd=2.52u as=0.3608p ps=2.52u w=0.82u l=1u
X578 VSS a_14432_11875# a_14392_12243# VSS nfet_05v0 ad=0.1053p pd=0.925u as=0.1782p ps=1.69u w=0.405u l=0.6u
X579 VDD.t2016 a_1916_7431# a_1828_7528# VDD.t1738 pfet_05v0 ad=0.5368p pd=3.32u as=0.5368p ps=3.32u w=1.22u l=1u
X580 a_3260_8999# a_3172_9096# VSS VSS nfet_05v0 ad=0.3608p pd=2.52u as=0.3608p ps=2.52u w=0.82u l=1u
X581 VDD.t2070 a_3260_12135# a_3172_12232# VDD.t1936 pfet_05v0 ad=0.5368p pd=3.32u as=0.5368p ps=3.32u w=1.22u l=1u
X582 a_3260_5863# a_3172_5960# VSS VSS nfet_05v0 ad=0.3608p pd=2.52u as=0.3608p ps=2.52u w=0.82u l=1u
X583 VDD.t1830 a_11100_6296# a_11012_6340# VDD.t1829 pfet_05v0 ad=0.5368p pd=3.32u as=0.5368p ps=3.32u w=1.22u l=1u
X584 VDD.t432 a_4156_17272# a_4068_17316# VDD.t431 pfet_05v0 ad=0.5368p pd=3.32u as=0.5368p ps=3.32u w=1.22u l=1u
X585 VDD.t1998 a_11100_3160# a_11012_3204# VDD.t1997 pfet_05v0 ad=0.5368p pd=3.32u as=0.5368p ps=3.32u w=1.22u l=1u
X586 VDD.t1882 a_8902_13040# dvo[2].t2 VDD.t1881 pfet_05v0 ad=0.3782p pd=1.84u as=0.5368p ps=3.32u w=1.22u l=0.5u
X587 VDD.t63 a_12892_6296# a_12804_6340# VDD.t62 pfet_05v0 ad=0.5368p pd=3.32u as=0.5368p ps=3.32u w=1.22u l=1u
X588 VDD.t1242 a_20284_4728# a_20196_4772# VDD.t1241 pfet_05v0 ad=0.5368p pd=3.32u as=0.5368p ps=3.32u w=1.22u l=1u
X589 VDD.t785 a_12892_3160# a_12804_3204# VDD.t784 pfet_05v0 ad=0.5368p pd=3.32u as=0.5368p ps=3.32u w=1.22u l=1u
X590 VDD.t746 a_20284_1592# a_20196_1636# VDD.t745 pfet_05v0 ad=0.5368p pd=3.32u as=0.5368p ps=3.32u w=1.22u l=1u
X591 a_12444_7864# a_12356_7908# VSS VSS nfet_05v0 ad=0.3608p pd=2.52u as=0.3608p ps=2.52u w=0.82u l=1u
X592 VDD.t2090 a_10032_11875# wire12.I VDD.t2089 pfet_05v0 ad=0.854p pd=3.84u as=0.3172p ps=1.74u w=1.22u l=0.5u
X593 a_20755_808# a_21085_808# a_21205_1406# VDD.t252 pfet_05v0 ad=0.3456p pd=2.64u as=61.19999f ps=0.7u w=0.36u l=0.5u
X594 a_12444_4728# a_12356_4772# VSS VSS nfet_05v0 ad=0.3608p pd=2.52u as=0.3608p ps=2.52u w=0.82u l=1u
X595 a_7292_14136# a_7204_14180# VSS VSS nfet_05v0 ad=0.3608p pd=2.52u as=0.3608p ps=2.52u w=0.82u l=1u
X596 VDD.t1248 a_7964_1159# a_7876_1256# VDD.t1247 pfet_05v0 ad=0.5368p pd=3.32u as=0.5368p ps=3.32u w=1.22u l=1u
X597 VDD.t777 a_4940_8999# a_4852_9096# VDD.t776 pfet_05v0 ad=0.5368p pd=3.32u as=0.5368p ps=3.32u w=1.22u l=1u
X598 VDD.t997 a_21068_12135# a_20980_12232# VDD.t996 pfet_05v0 ad=0.5368p pd=3.32u as=0.5368p ps=3.32u w=1.22u l=1u
X599 VDD.t336 a_3708_4728# a_3620_4772# VDD.t137 pfet_05v0 ad=0.5368p pd=3.32u as=0.5368p ps=3.32u w=1.22u l=1u
X600 VDD.t2054 a_16252_18407# a_16164_18504# VDD.t2053 pfet_05v0 ad=0.5368p pd=3.32u as=0.5368p ps=3.32u w=1.22u l=1u
X601 a_21180_17272# a_21092_17316# VSS VSS nfet_05v0 ad=0.3608p pd=2.52u as=0.3608p ps=2.52u w=0.82u l=1u
X602 a_7292_11000# a_7204_11044# VSS VSS nfet_05v0 ad=0.3608p pd=2.52u as=0.3608p ps=2.52u w=0.82u l=1u
X603 a_11324_18407# a_11236_18504# VSS VSS nfet_05v0 ad=0.3608p pd=2.52u as=0.3608p ps=2.52u w=0.82u l=1u
X604 VDD.t243 a_3708_1592# a_3620_1636# VDD.t242 pfet_05v0 ad=0.5368p pd=3.32u as=0.5368p ps=3.32u w=1.22u l=1u
X605 wire20.I a_13272_13352# VDD.t2036 VDD.t2035 pfet_05v0 ad=0.3172p pd=1.74u as=0.854p ps=3.84u w=1.22u l=0.5u
X606 a_17685_1428# a_17565_808# a_16941_808# VDD.t1810 pfet_05v0 ad=61.19999f pd=0.7u as=0.3852p ps=2.86u w=0.36u l=0.5u
X607 VDD.t1921 a_18156_7431# a_18068_7528# VDD.t1920 pfet_05v0 ad=0.5368p pd=3.32u as=0.5368p ps=3.32u w=1.22u l=1u
X608 a_3708_1159# a_3620_1256# VSS VSS nfet_05v0 ad=0.3608p pd=2.52u as=0.3608p ps=2.52u w=0.82u l=1u
X609 a_14432_11875# ana_div_chain\[1\]_dff_notouch_.CLK VDD.t1572 VDD.t1571 pfet_05v0 ad=0.3806p pd=2.61u as=0.2249p ps=1.385u w=0.865u l=0.5u
X610 a_8902_13040# dac_div_chain\[1\]_inv_notouch_.I VDD.t1880 VDD.t1879 pfet_05v0 ad=0.5368p pd=3.32u as=0.4941p ps=2.03u w=1.22u l=0.5u
X611 a_1916_17272# a_1828_17316# VSS VSS nfet_05v0 ad=0.3608p pd=2.52u as=0.3608p ps=2.52u w=0.82u l=1u
X612 a_11324_1159# a_11236_1256# VSS VSS nfet_05v0 ad=0.3608p pd=2.52u as=0.3608p ps=2.52u w=0.82u l=1u
X613 VDD.t27 a_4156_4295# a_4068_4392# VDD.t26 pfet_05v0 ad=0.5368p pd=3.32u as=0.5368p ps=3.32u w=1.22u l=1u
X614 a_7740_12568# a_7652_12612# VSS VSS nfet_05v0 ad=0.3608p pd=2.52u as=0.3608p ps=2.52u w=0.82u l=1u
X615 VDD.t290 a_4156_1159# a_4068_1256# VDD.t289 pfet_05v0 ad=0.5368p pd=3.32u as=0.5368p ps=3.32u w=1.22u l=1u
X616 ana_div_chain\[2\]_dff_notouch_.CLK a_10340_13143# VSS VSS nfet_05v0 ad=0.2178p pd=1.87u as=0.153p ps=1.195u w=0.495u l=0.6u
X617 VSS a_4819_18100# a_4819_18100# VSS nfet_05v0 ad=0.3608p pd=2.52u as=0.3608p ps=2.52u w=0.82u l=0.6u
X618 a_8860_7864# a_8772_7908# VSS VSS nfet_05v0 ad=0.3608p pd=2.52u as=0.3608p ps=2.52u w=0.82u l=1u
X619 a_8860_4728# a_8772_4772# VSS VSS nfet_05v0 ad=0.3608p pd=2.52u as=0.3608p ps=2.52u w=0.82u l=1u
X620 a_13676_10567# a_13588_10664# VSS VSS nfet_05v0 ad=0.3608p pd=2.52u as=0.3608p ps=2.52u w=0.82u l=1u
X621 ana_div_chain\[4\]_dff_notouch_.Q a_18208_16579# VDD.t1604 VDD.t1603 pfet_05v0 ad=0.3172p pd=1.74u as=0.5368p ps=3.32u w=1.22u l=0.5u
X622 a_7180_15271# a_7092_15368# VSS VSS nfet_05v0 ad=0.3608p pd=2.52u as=0.3608p ps=2.52u w=0.82u l=1u
X623 a_4156_15271# a_4068_15368# VSS VSS nfet_05v0 ad=0.3608p pd=2.52u as=0.3608p ps=2.52u w=0.82u l=1u
X624 VDD.t1842 a_7628_8999# a_7540_9096# VDD.t1841 pfet_05v0 ad=0.5368p pd=3.32u as=0.5368p ps=3.32u w=1.22u l=1u
X625 a_7180_12135# a_7092_12232# VSS VSS nfet_05v0 ad=0.3608p pd=2.52u as=0.3608p ps=2.52u w=0.82u l=1u
X626 a_4156_12135# a_4068_12232# VSS VSS nfet_05v0 ad=0.3608p pd=2.52u as=0.3608p ps=2.52u w=0.82u l=1u
X627 a_5052_7864# a_4964_7908# VSS VSS nfet_05v0 ad=0.3608p pd=2.52u as=0.3608p ps=2.52u w=0.82u l=1u
X628 a_19500_4295# a_19412_4392# VSS VSS nfet_05v0 ad=0.3608p pd=2.52u as=0.3608p ps=2.52u w=0.82u l=1u
X629 a_5052_4728# a_4964_4772# VSS VSS nfet_05v0 ad=0.3608p pd=2.52u as=0.3608p ps=2.52u w=0.82u l=1u
X630 VDD.t2060 a_12444_7864# a_12356_7908# VDD.t2059 pfet_05v0 ad=0.5368p pd=3.32u as=0.5368p ps=3.32u w=1.22u l=1u
X631 ana_div_chain\[4\]_dff_notouch_.Q a_18208_16579# VSS VSS nfet_05v0 ad=0.2132p pd=1.34u as=0.3608p ps=2.52u w=0.82u l=0.6u
X632 a_5836_2727# a_5748_2824# VSS VSS nfet_05v0 ad=0.3608p pd=2.52u as=0.3608p ps=2.52u w=0.82u l=1u
X633 VDD.t771 a_1683_18100# uio_oe[6].t0 VDD.t770 pfet_05v0 ad=0.5368p pd=3.32u as=0.5368p ps=3.32u w=1.22u l=0.5u
X634 VDD.t1094 a_7740_15704# a_7652_15748# VDD.t1093 pfet_05v0 ad=0.5368p pd=3.32u as=0.5368p ps=3.32u w=1.22u l=1u
X635 VDD.t1062 a_19500_12135# a_19412_12232# VDD.t1061 pfet_05v0 ad=0.5368p pd=3.32u as=0.5368p ps=3.32u w=1.22u l=1u
X636 VDD.t1731 a_8188_6296# a_8100_6340# VDD.t1730 pfet_05v0 ad=0.5368p pd=3.32u as=0.5368p ps=3.32u w=1.22u l=1u
X637 a_2812_7431# a_2724_7528# VSS VSS nfet_05v0 ad=0.3608p pd=2.52u as=0.3608p ps=2.52u w=0.82u l=1u
X638 VDD.t1325 a_1916_9432# a_1828_9476# VDD.t1164 pfet_05v0 ad=0.5368p pd=3.32u as=0.5368p ps=3.32u w=1.22u l=1u
X639 a_9308_17272# a_9220_17316# VSS VSS nfet_05v0 ad=0.3608p pd=2.52u as=0.3608p ps=2.52u w=0.82u l=1u
X640 a_14768_13443# a_14320_13443# a_15180_13855# VDD.t1369 pfet_05v0 ad=0.1872p pd=1.4u as=43.2f ps=0.6u w=0.36u l=0.5u
X641 VDD.t935 a_8188_3160# a_8100_3204# VDD.t934 pfet_05v0 ad=0.5368p pd=3.32u as=0.5368p ps=3.32u w=1.22u l=1u
X642 a_9056_11919# a_8176_12232# a_8732_11919# VSS nfet_05v0 ad=43.2f pd=0.6u as=0.207p ps=1.51u w=0.36u l=0.6u
X643 VDD.t1142 a_8860_7864# a_8772_7908# VDD.t1141 pfet_05v0 ad=0.5368p pd=3.32u as=0.5368p ps=3.32u w=1.22u l=1u
X644 VDD.t1479 a_3260_14136# a_3172_14180# VDD.t599 pfet_05v0 ad=0.5368p pd=3.32u as=0.5368p ps=3.32u w=1.22u l=1u
X645 VDD.t1046 a_3260_11000# a_3172_11044# VDD.t627 pfet_05v0 ad=0.5368p pd=3.32u as=0.5368p ps=3.32u w=1.22u l=1u
X646 a_7516_1159# a_7428_1256# VSS VSS nfet_05v0 ad=0.3608p pd=2.52u as=0.3608p ps=2.52u w=0.82u l=1u
X647 a_15132_1159# a_15044_1256# VSS VSS nfet_05v0 ad=0.3608p pd=2.52u as=0.3608p ps=2.52u w=0.82u l=1u
X648 VDD.t29 a_5388_4295# a_5300_4392# VDD.t28 pfet_05v0 ad=0.5368p pd=3.32u as=0.5368p ps=3.32u w=1.22u l=1u
X649 VDD.t2006 a_18492_4728# a_18404_4772# VDD.t2005 pfet_05v0 ad=0.5368p pd=3.32u as=0.5368p ps=3.32u w=1.22u l=1u
X650 VDD.t1163 a_2364_8999# a_2276_9096# VDD.t1162 pfet_05v0 ad=0.5368p pd=3.32u as=0.5368p ps=3.32u w=1.22u l=1u
X651 dvo[2].t0 a_8902_13040# VDD.t1884 VDD.t1883 pfet_05v0 ad=0.3782p pd=1.84u as=0.3782p ps=1.84u w=1.22u l=0.5u
X652 VDD.t1803 a_18492_1592# a_18404_1636# VDD.t1802 pfet_05v0 ad=0.5368p pd=3.32u as=0.5368p ps=3.32u w=1.22u l=1u
X653 a_19596_13097# ana_div_chain\[0\]_dff_notouch_.D a_19428_13097# VSS nfet_05v0 ad=0.207p pd=1.51u as=43.2f ps=0.6u w=0.36u l=0.6u
X654 VDD.t644 a_5052_7864# a_4964_7908# VDD.t643 pfet_05v0 ad=0.5368p pd=3.32u as=0.5368p ps=3.32u w=1.22u l=1u
X655 a_1020_15704# a_932_15748# VSS VSS nfet_05v0 ad=0.3608p pd=2.52u as=0.3608p ps=2.52u w=0.82u l=1u
X656 a_11772_18407# a_11684_18504# VSS VSS nfet_05v0 ad=0.3608p pd=2.52u as=0.3608p ps=2.52u w=0.82u l=1u
X657 a_7628_16839# a_7540_16936# VSS VSS nfet_05v0 ad=0.3608p pd=2.52u as=0.3608p ps=2.52u w=0.82u l=1u
X658 dvo[1].t0 a_14708_12612# VSS VSS nfet_05v0 ad=0.2132p pd=1.34u as=0.2911p ps=1.53u w=0.82u l=0.6u
X659 a_18044_3160# a_17956_3204# VSS VSS nfet_05v0 ad=0.3608p pd=2.52u as=0.3608p ps=2.52u w=0.82u l=1u
X660 dac_div_chain\[4\]_dff_notouch_.Q a_13168_16189# VSS VSS nfet_05v0 ad=0.2132p pd=1.34u as=0.3608p ps=2.52u w=0.82u l=0.6u
X661 VDD.t464 a_10764_4295# a_10676_4392# VDD.t463 pfet_05v0 ad=0.5368p pd=3.32u as=0.5368p ps=3.32u w=1.22u l=1u
X662 a_8176_12232# a_7764_11911# VDD.t1667 VDD.t1666 pfet_05v0 ad=0.3806p pd=2.61u as=0.2249p ps=1.385u w=0.865u l=0.5u
X663 VDD.t1807 a_8636_1159# a_8548_1256# VDD.t1806 pfet_05v0 ad=0.5368p pd=3.32u as=0.5368p ps=3.32u w=1.22u l=1u
X664 a_6508_18407# a_6420_18504# VSS VSS nfet_05v0 ad=0.3608p pd=2.52u as=0.3608p ps=2.52u w=0.82u l=1u
X665 a_8972_8999# a_8884_9096# VSS VSS nfet_05v0 ad=0.3608p pd=2.52u as=0.3608p ps=2.52u w=0.82u l=1u
X666 VDD.t1098 a_6051_18100# uio_oe[3].t0 VDD.t1097 pfet_05v0 ad=0.5368p pd=3.32u as=0.5368p ps=3.32u w=1.22u l=0.5u
X667 VDD.t763 a_11256_16533# dac_div_chain\[4\]_dff_notouch_.CLK VDD.t762 pfet_05v0 ad=0.4015p pd=1.92u as=0.5368p ps=3.32u w=1.22u l=0.5u
X668 a_8972_5863# a_8884_5960# VSS VSS nfet_05v0 ad=0.3608p pd=2.52u as=0.3608p ps=2.52u w=0.82u l=1u
X669 a_15264_15011# a_14892_15055# VDD.t462 VDD.t461 pfet_05v0 ad=0.1791p pd=1.355u as=0.1044p ps=0.94u w=0.36u l=0.5u
X670 a_19052_7431# a_18964_7528# VSS VSS nfet_05v0 ad=0.3608p pd=2.52u as=0.3608p ps=2.52u w=0.82u l=1u
X671 a_3708_14136# a_3620_14180# VSS VSS nfet_05v0 ad=0.3608p pd=2.52u as=0.3608p ps=2.52u w=0.82u l=1u
X672 VDD.t954 a_20896_13053# a_20888_12729# VDD.t953 pfet_05v0 ad=0.23p pd=1.54u as=50.4f ps=0.64u w=0.36u l=0.5u
X673 a_3708_11000# a_3620_11044# VSS VSS nfet_05v0 ad=0.3608p pd=2.52u as=0.3608p ps=2.52u w=0.82u l=1u
X674 a_1916_4295# a_1828_4392# VSS VSS nfet_05v0 ad=0.3608p pd=2.52u as=0.3608p ps=2.52u w=0.82u l=1u
X675 VDD.t1144 a_5388_16839# a_5300_16936# VDD.t1143 pfet_05v0 ad=0.5368p pd=3.32u as=0.5368p ps=3.32u w=1.22u l=1u
X676 VSS wire20.I a_14708_12612# VSS nfet_05v0 ad=0.2911p pd=1.53u as=0.3608p ps=2.52u w=0.82u l=0.6u
X677 a_9756_17272# a_9668_17316# VSS VSS nfet_05v0 ad=0.3608p pd=2.52u as=0.3608p ps=2.52u w=0.82u l=1u
X678 VSS a_18208_16579# ana_div_chain\[4\]_dff_notouch_.Q VSS nfet_05v0 ad=0.3608p pd=2.52u as=0.2132p ps=1.34u w=0.82u l=0.6u
X679 VSS a_15848_17776# ana_div_chain\[4\]_dff_notouch_.CLK VSS nfet_05v0 ad=0.153p pd=1.195u as=0.2178p ps=1.87u w=0.495u l=0.6u
X680 VDD.t1348 a_20284_17272# a_20196_17316# VDD.t1347 pfet_05v0 ad=0.5368p pd=3.32u as=0.5368p ps=3.32u w=1.22u l=1u
X681 VDD.t1690 a_5836_15271# a_5748_15368# VDD.t1689 pfet_05v0 ad=0.5368p pd=3.32u as=0.5368p ps=3.32u w=1.22u l=1u
X682 VDD.t113 a_9868_4295# a_9780_4392# VDD.t112 pfet_05v0 ad=0.5368p pd=3.32u as=0.5368p ps=3.32u w=1.22u l=1u
X683 a_19472_12729# a_19040_12683# VDD.t527 VDD.t526 pfet_05v0 ad=54f pd=0.66u as=0.4554p ps=3.25u w=0.36u l=0.5u
X684 VDD.t1541 a_17752_18101# ana_div_chain\[4\]_inv_notouch_.I VDD.t1540 pfet_05v0 ad=0.4015p pd=1.92u as=0.5368p ps=3.32u w=1.22u l=0.5u
X685 a_14336_12287# a_13384_11784# VDD.t1299 VDD.t1298 pfet_05v0 ad=50.4f pd=0.64u as=0.23p ps=1.54u w=0.36u l=0.5u
X686 a_11100_7864# a_11012_7908# VSS VSS nfet_05v0 ad=0.3608p pd=2.52u as=0.3608p ps=2.52u w=0.82u l=1u
X687 a_11100_4728# a_11012_4772# VSS VSS nfet_05v0 ad=0.3608p pd=2.52u as=0.3608p ps=2.52u w=0.82u l=1u
X688 VDD.t1800 a_6620_1159# a_6532_1256# VDD.t1799 pfet_05v0 ad=0.5368p pd=3.32u as=0.5368p ps=3.32u w=1.22u l=1u
X689 VDD.t542 a_19388_9432# a_19300_9476# VDD.t541 pfet_05v0 ad=0.5368p pd=3.32u as=0.5368p ps=3.32u w=1.22u l=1u
X690 a_20888_12729# a_19040_12683# a_20603_12729# VDD.t528 pfet_05v0 ad=50.4f pd=0.64u as=0.1665p ps=1.285u w=0.36u l=0.5u
X691 a_13228_15271# a_13140_15368# VSS VSS nfet_05v0 ad=0.3608p pd=2.52u as=0.3608p ps=2.52u w=0.82u l=1u
X692 a_2364_1592# a_2276_1636# VSS VSS nfet_05v0 ad=0.3608p pd=2.52u as=0.3608p ps=2.52u w=0.82u l=1u
X693 a_18156_4295# a_18068_4392# VSS VSS nfet_05v0 ad=0.3608p pd=2.52u as=0.3608p ps=2.52u w=0.82u l=1u
X694 a_12892_7864# a_12804_7908# VSS VSS nfet_05v0 ad=0.3608p pd=2.52u as=0.3608p ps=2.52u w=0.82u l=1u
X695 a_19388_17272# a_19300_17316# VSS VSS nfet_05v0 ad=0.3608p pd=2.52u as=0.3608p ps=2.52u w=0.82u l=1u
X696 a_13228_8999# a_13140_9096# VSS VSS nfet_05v0 ad=0.3608p pd=2.52u as=0.3608p ps=2.52u w=0.82u l=1u
X697 a_12892_4728# a_12804_4772# VSS VSS nfet_05v0 ad=0.3608p pd=2.52u as=0.3608p ps=2.52u w=0.82u l=1u
X698 a_20284_3160# a_20196_3204# VSS VSS nfet_05v0 ad=0.3608p pd=2.52u as=0.3608p ps=2.52u w=0.82u l=1u
X699 a_13228_5863# a_13140_5960# VSS VSS nfet_05v0 ad=0.3608p pd=2.52u as=0.3608p ps=2.52u w=0.82u l=1u
X700 a_6732_10567# a_6644_10664# VSS VSS nfet_05v0 ad=0.3608p pd=2.52u as=0.3608p ps=2.52u w=0.82u l=1u
X701 a_6956_18407# a_6868_18504# VSS VSS nfet_05v0 ad=0.3608p pd=2.52u as=0.3608p ps=2.52u w=0.82u l=1u
X702 a_16700_13703# a_16612_13800# VSS VSS nfet_05v0 ad=0.3608p pd=2.52u as=0.3608p ps=2.52u w=0.82u l=1u
X703 VDD.t2011 a_14236_6296# a_14148_6340# VDD.t2010 pfet_05v0 ad=0.5368p pd=3.32u as=0.5368p ps=3.32u w=1.22u l=1u
X704 VSS a_13168_16189# dac_div_chain\[4\]_dff_notouch_.Q VSS nfet_05v0 ad=0.3608p pd=2.52u as=0.2132p ps=1.34u w=0.82u l=0.6u
X705 VDD.t1939 a_14236_3160# a_14148_3204# VDD.t1938 pfet_05v0 ad=0.5368p pd=3.32u as=0.5368p ps=3.32u w=1.22u l=1u
X706 a_3708_10567# a_3620_10664# VSS VSS nfet_05v0 ad=0.3608p pd=2.52u as=0.3608p ps=2.52u w=0.82u l=1u
X707 a_1468_7431# a_1380_7528# VSS VSS nfet_05v0 ad=0.3608p pd=2.52u as=0.3608p ps=2.52u w=0.82u l=1u
X708 a_3708_3160# a_3620_3204# VSS VSS nfet_05v0 ad=0.3608p pd=2.52u as=0.3608p ps=2.52u w=0.82u l=1u
X709 VDD.t1398 a_6844_12568# a_6756_12612# VDD.t1397 pfet_05v0 ad=0.5368p pd=3.32u as=0.5368p ps=3.32u w=1.22u l=1u
X710 VDD.t817 a_3260_16839# a_3172_16936# VDD.t816 pfet_05v0 ad=0.5368p pd=3.32u as=0.5368p ps=3.32u w=1.22u l=1u
X711 VDD.t928 a_11264_13443# dac_div_chain\[3\]_inv_notouch_.I VDD.t927 pfet_05v0 ad=0.854p pd=3.84u as=0.3172p ps=1.74u w=1.22u l=0.5u
X712 VDD.t1650 ana_div_chain\[2\]_dff_notouch_.CLK a_11012_11528# VDD.t1649 pfet_05v0 ad=0.2249p pd=1.385u as=0.3806p ps=2.61u w=0.865u l=0.5u
X713 VSS a_9104_11875# a_9056_11919# VSS nfet_05v0 ad=0.2637p pd=1.825u as=43.2f ps=0.6u w=0.36u l=0.6u
X714 VDD.t195 a_21068_7431# a_20980_7528# VDD.t194 pfet_05v0 ad=0.5368p pd=3.32u as=0.5368p ps=3.32u w=1.22u l=1u
X715 VSS a_11478_11784# avo[3].t5 VSS nfet_05v0 ad=0.2911p pd=1.53u as=0.2132p ps=1.34u w=0.82u l=0.6u
X716 VDD.t497 input1.Z a_20420_14180# VDD.t496 pfet_05v0 ad=0.4941p pd=2.03u as=0.5368p ps=3.32u w=1.22u l=0.5u
X717 VDD.t1933 a_11100_7864# a_11012_7908# VDD.t1932 pfet_05v0 ad=0.5368p pd=3.32u as=0.5368p ps=3.32u w=1.22u l=1u
X718 a_11478_11784# ana_div_chain\[2\]_dff_notouch_.Q VDD.t909 VDD.t908 pfet_05v0 ad=0.5368p pd=3.32u as=0.4941p ps=2.03u w=1.22u l=0.5u
X719 a_4604_17272# a_4516_17316# VSS VSS nfet_05v0 ad=0.3608p pd=2.52u as=0.3608p ps=2.52u w=0.82u l=1u
X720 VDD.t1523 a_2140_18407# a_2052_18504# VDD.t1522 pfet_05v0 ad=0.5368p pd=3.32u as=0.5368p ps=3.32u w=1.22u l=1u
X721 VDD.t924 a_11264_13443# a_11256_13855# VDD.t923 pfet_05v0 ad=0.23p pd=1.54u as=50.4f ps=0.64u w=0.36u l=0.5u
X722 a_16364_10567# a_16276_10664# VSS VSS nfet_05v0 ad=0.3608p pd=2.52u as=0.3608p ps=2.52u w=0.82u l=1u
X723 VDD.t2096 a_12892_7864# a_12804_7908# VDD.t2095 pfet_05v0 ad=0.5368p pd=3.32u as=0.5368p ps=3.32u w=1.22u l=1u
X724 a_18380_1159# a_18292_1256# VSS VSS nfet_05v0 ad=0.3608p pd=2.52u as=0.3608p ps=2.52u w=0.82u l=1u
X725 VDD.t1202 a_21068_16839# a_20980_16936# VDD.t1201 pfet_05v0 ad=0.5368p pd=3.32u as=0.5368p ps=3.32u w=1.22u l=1u
X726 VDD.t562 a_1468_10567# a_1380_10664# VDD.t561 pfet_05v0 ad=0.5368p pd=3.32u as=0.5368p ps=3.32u w=1.22u l=1u
X727 a_14728_14640# dvo[1].t7 VSS VSS nfet_05v0 ad=0.1584p pd=1.6u as=0.153p ps=1.195u w=0.36u l=0.6u
X728 VDD.t1472 a_1020_8999# a_932_9096# VDD.t812 pfet_05v0 ad=0.5368p pd=3.32u as=0.5368p ps=3.32u w=1.22u l=1u
X729 VDD.t1082 a_20844_15704# a_20756_15748# VDD.t1081 pfet_05v0 ad=0.5368p pd=3.32u as=0.5368p ps=3.32u w=1.22u l=1u
X730 VDD.t346 a_2812_5863# a_2724_5960# VDD.t345 pfet_05v0 ad=0.5368p pd=3.32u as=0.5368p ps=3.32u w=1.22u l=1u
X731 a_11212_8999# a_11124_9096# VSS VSS nfet_05v0 ad=0.3608p pd=2.52u as=0.3608p ps=2.52u w=0.82u l=1u
X732 VDD.t843 a_7292_17272# a_7204_17316# VDD.t842 pfet_05v0 ad=0.5368p pd=3.32u as=0.5368p ps=3.32u w=1.22u l=1u
X733 VDD.t1422 a_21516_15271# a_21428_15368# VDD.t1421 pfet_05v0 ad=0.5368p pd=3.32u as=0.5368p ps=3.32u w=1.22u l=1u
X734 VDD.t390 a_2812_2727# a_2724_2824# VDD.t389 pfet_05v0 ad=0.5368p pd=3.32u as=0.5368p ps=3.32u w=1.22u l=1u
X735 a_11212_5863# a_11124_5960# VSS VSS nfet_05v0 ad=0.3608p pd=2.52u as=0.3608p ps=2.52u w=0.82u l=1u
X736 a_8188_7864# a_8100_7908# VSS VSS nfet_05v0 ad=0.3608p pd=2.52u as=0.3608p ps=2.52u w=0.82u l=1u
X737 VDD.t1198 a_10316_15271# a_10228_15368# VDD.t1197 pfet_05v0 ad=0.5368p pd=3.32u as=0.5368p ps=3.32u w=1.22u l=1u
X738 a_6844_1592# a_6756_1636# VSS VSS nfet_05v0 ad=0.3608p pd=2.52u as=0.3608p ps=2.52u w=0.82u l=1u
X739 a_8188_4728# a_8100_4772# VSS VSS nfet_05v0 ad=0.3608p pd=2.52u as=0.3608p ps=2.52u w=0.82u l=1u
X740 a_3260_12568# a_3172_12612# VSS VSS nfet_05v0 ad=0.3608p pd=2.52u as=0.3608p ps=2.52u w=0.82u l=1u
X741 VDD.t2084 a_11478_11784# avo[3].t1 VDD.t2083 pfet_05v0 ad=0.4941p pd=2.03u as=0.3782p ps=1.84u w=1.22u l=0.5u
X742 a_17708_8999# a_17620_9096# VSS VSS nfet_05v0 ad=0.3608p pd=2.52u as=0.3608p ps=2.52u w=0.82u l=1u
X743 a_17708_5863# a_17620_5960# VSS VSS nfet_05v0 ad=0.3608p pd=2.52u as=0.3608p ps=2.52u w=0.82u l=1u
X744 a_11256_13855# a_9408_13800# a_10971_13855# VDD.t1280 pfet_05v0 ad=50.4f pd=0.64u as=0.1665p ps=1.285u w=0.36u l=0.5u
X745 a_18492_3160# a_18404_3204# VSS VSS nfet_05v0 ad=0.3608p pd=2.52u as=0.3608p ps=2.52u w=0.82u l=1u
X746 VDD.t1911 a_15916_4295# a_15828_4392# VDD.t1910 pfet_05v0 ad=0.5368p pd=3.32u as=0.5368p ps=3.32u w=1.22u l=1u
X747 VDD.t521 a_17932_15271# a_17844_15368# VDD.t520 pfet_05v0 ad=0.5368p pd=3.32u as=0.5368p ps=3.32u w=1.22u l=1u
X748 VDD.t1600 a_19500_16839# a_19412_16936# VDD.t1599 pfet_05v0 ad=0.5368p pd=3.32u as=0.5368p ps=3.32u w=1.22u l=1u
X749 VDD.t364 a_12108_4295# a_12020_4392# VDD.t363 pfet_05v0 ad=0.5368p pd=3.32u as=0.5368p ps=3.32u w=1.22u l=1u
X750 VDD.t1761 a_19052_5863# a_18964_5960# VDD.t1760 pfet_05v0 ad=0.5368p pd=3.32u as=0.5368p ps=3.32u w=1.22u l=1u
X751 VDD.t1225 a_8188_7864# a_8100_7908# VDD.t1224 pfet_05v0 ad=0.5368p pd=3.32u as=0.5368p ps=3.32u w=1.22u l=1u
X752 VDD.t738 a_19052_2727# a_18964_2824# VDD.t737 pfet_05v0 ad=0.5368p pd=3.32u as=0.5368p ps=3.32u w=1.22u l=1u
X753 VDD.t17 a_5276_1159# a_5188_1256# VDD.t16 pfet_05v0 ad=0.5368p pd=3.32u as=0.5368p ps=3.32u w=1.22u l=1u
X754 VDD.t1466 a_3260_15704# a_3172_15748# VDD.t1030 pfet_05v0 ad=0.5368p pd=3.32u as=0.5368p ps=3.32u w=1.22u l=1u
X755 a_21740_15704# a_21652_15748# VSS VSS nfet_05v0 ad=0.3608p pd=2.52u as=0.3608p ps=2.52u w=0.82u l=1u
X756 a_11744_15865# a_11312_15819# VDD.t1049 VDD.t1048 pfet_05v0 ad=54f pd=0.66u as=0.4554p ps=3.25u w=0.36u l=0.5u
X757 VDD.t356 a_8524_4295# a_8436_4392# VDD.t355 pfet_05v0 ad=0.5368p pd=3.32u as=0.5368p ps=3.32u w=1.22u l=1u
X758 VDD.t829 a_8076_16839# a_7988_16936# VDD.t828 pfet_05v0 ad=0.5368p pd=3.32u as=0.5368p ps=3.32u w=1.22u l=1u
X759 VDD.t400 a_17708_10567# a_17620_10664# VDD.t399 pfet_05v0 ad=0.5368p pd=3.32u as=0.5368p ps=3.32u w=1.22u l=1u
X760 VDD.t1044 a_21964_15271# a_21876_15368# VDD.t1043 pfet_05v0 ad=0.5368p pd=3.32u as=0.5368p ps=3.32u w=1.22u l=1u
X761 VDD.t1996 a_16700_6296# a_16612_6340# VDD.t1995 pfet_05v0 ad=0.5368p pd=3.32u as=0.5368p ps=3.32u w=1.22u l=1u
X762 VSS a_8902_13040# dvo[2].t5 VSS nfet_05v0 ad=0.2911p pd=1.53u as=0.2132p ps=1.34u w=0.82u l=0.6u
X763 VDD.t1196 a_10764_15271# a_10676_15368# VDD.t1195 pfet_05v0 ad=0.5368p pd=3.32u as=0.5368p ps=3.32u w=1.22u l=1u
X764 VDD.t279 a_18044_9432# a_17956_9476# VDD.t278 pfet_05v0 ad=0.5368p pd=3.32u as=0.5368p ps=3.32u w=1.22u l=1u
X765 VDD.t475 a_17148_14136# a_17060_14180# VDD.t474 pfet_05v0 ad=0.5368p pd=3.32u as=0.5368p ps=3.32u w=1.22u l=1u
X766 VDD.t921 a_2364_13703# a_2276_13800# VDD.t822 pfet_05v0 ad=0.5368p pd=3.32u as=0.5368p ps=3.32u w=1.22u l=1u
X767 VDD.t728 a_16700_3160# a_16612_3204# VDD.t727 pfet_05v0 ad=0.5368p pd=3.32u as=0.5368p ps=3.32u w=1.22u l=1u
X768 VDD.t685 a_15916_12568# a_15828_12612# VDD.t684 pfet_05v0 ad=0.5368p pd=3.32u as=0.5368p ps=3.32u w=1.22u l=1u
X769 a_1020_1592# a_932_1636# VSS VSS nfet_05v0 ad=0.3608p pd=2.52u as=0.3608p ps=2.52u w=0.82u l=1u
X770 VDD.t312 a_3708_7431# a_3620_7528# VDD.t311 pfet_05v0 ad=0.5368p pd=3.32u as=0.5368p ps=3.32u w=1.22u l=1u
X771 VDD.t917 a_17148_11000# a_17060_11044# VDD.t916 pfet_05v0 ad=0.5368p pd=3.32u as=0.5368p ps=3.32u w=1.22u l=1u
X772 a_11812_11529# a_11012_11528# VSS VSS nfet_05v0 ad=43.2f pd=0.6u as=0.1584p ps=1.6u w=0.36u l=0.6u
X773 VDD.t1434 a_8524_15271# a_8436_15368# VDD.t1433 pfet_05v0 ad=0.5368p pd=3.32u as=0.5368p ps=3.32u w=1.22u l=1u
X774 VSS ana_div_chain\[3\]_inv_notouch_.I a_16612_17316# VSS nfet_05v0 ad=0.2911p pd=1.53u as=0.3608p ps=2.52u w=0.82u l=0.6u
X775 a_9964_13487# dac_div_chain\[3\]_inv_notouch_.ZN a_9796_13487# VSS nfet_05v0 ad=0.207p pd=1.51u as=43.2f ps=0.6u w=0.36u l=0.6u
X776 VDD.t51 a_2812_4728# a_2724_4772# VDD.t50 pfet_05v0 ad=0.5368p pd=3.32u as=0.5368p ps=3.32u w=1.22u l=1u
X777 VDD.t465 a_2812_1592# a_2724_1636# VDD.t229 pfet_05v0 ad=0.5368p pd=3.32u as=0.5368p ps=3.32u w=1.22u l=1u
X778 VDD.t2071 a_2812_12135# a_2724_12232# VDD.t1511 pfet_05v0 ad=0.5368p pd=3.32u as=0.5368p ps=3.32u w=1.22u l=1u
X779 VDD.t656 a_10316_8999# a_10228_9096# VDD.t655 pfet_05v0 ad=0.5368p pd=3.32u as=0.5368p ps=3.32u w=1.22u l=1u
X780 a_11856_11161# a_11424_11115# VDD.t808 VDD.t807 pfet_05v0 ad=54f pd=0.66u as=0.4554p ps=3.25u w=0.36u l=0.5u
X781 VDD.t1297 a_13384_11784# wire18.I VDD.t1296 pfet_05v0 ad=0.5368p pd=3.32u as=0.3172p ps=1.74u w=1.22u l=0.5u
X782 ana_div_chain\[2\]_inv_notouch_.ZN ana_div_chain\[2\]_inv_notouch_.I VDD.t1019 VDD.t1018 pfet_05v0 ad=0.5368p pd=3.32u as=0.5368p ps=3.32u w=1.22u l=0.5u
X783 VDD.t854 a_17260_7431# a_17172_7528# VDD.t853 pfet_05v0 ad=0.5368p pd=3.32u as=0.5368p ps=3.32u w=1.22u l=1u
X784 VDD.t1469 a_3708_17272# a_3620_17316# VDD.t814 pfet_05v0 ad=0.5368p pd=3.32u as=0.5368p ps=3.32u w=1.22u l=1u
X785 a_13676_8999# a_13588_9096# VSS VSS nfet_05v0 ad=0.3608p pd=2.52u as=0.3608p ps=2.52u w=0.82u l=1u
X786 VDD.t335 a_3260_4295# a_3172_4392# VDD.t334 pfet_05v0 ad=0.5368p pd=3.32u as=0.5368p ps=3.32u w=1.22u l=1u
X787 a_13676_5863# a_13588_5960# VSS VSS nfet_05v0 ad=0.3608p pd=2.52u as=0.3608p ps=2.52u w=0.82u l=1u
X788 VDD.t2009 a_14684_6296# a_14596_6340# VDD.t2008 pfet_05v0 ad=0.5368p pd=3.32u as=0.5368p ps=3.32u w=1.22u l=1u
X789 a_21068_4295# a_20980_4392# VSS VSS nfet_05v0 ad=0.3608p pd=2.52u as=0.3608p ps=2.52u w=0.82u l=1u
X790 VDD.t7 a_3260_1159# a_3172_1256# VDD.t6 pfet_05v0 ad=0.5368p pd=3.32u as=0.5368p ps=3.32u w=1.22u l=1u
X791 VDD.t602 a_14684_3160# a_14596_3204# VDD.t601 pfet_05v0 ad=0.5368p pd=3.32u as=0.5368p ps=3.32u w=1.22u l=1u
X792 VDD.t1948 a_22076_4728# a_21988_4772# VDD.t1947 pfet_05v0 ad=0.5368p pd=3.32u as=0.5368p ps=3.32u w=1.22u l=1u
X793 VDD.t408 a_13788_18407# a_13700_18504# VDD.t407 pfet_05v0 ad=0.5368p pd=3.32u as=0.5368p ps=3.32u w=1.22u l=1u
X794 VDD.t166 a_22076_1592# a_21988_1636# VDD.t165 pfet_05v0 ad=0.5368p pd=3.32u as=0.5368p ps=3.32u w=1.22u l=1u
X795 avo[5].t4 a_17862_17744# VDD.t1700 VDD.t1699 pfet_05v0 ad=0.3782p pd=1.84u as=0.3782p ps=1.84u w=1.22u l=0.5u
X796 a_14236_7864# a_14148_7908# VSS VSS nfet_05v0 ad=0.3608p pd=2.52u as=0.3608p ps=2.52u w=0.82u l=1u
X797 avo[4].t2 a_16612_17316# VSS VSS nfet_05v0 ad=0.3608p pd=2.52u as=0.2132p ps=1.34u w=0.82u l=0.6u
X798 a_14236_4728# a_14148_4772# VSS VSS nfet_05v0 ad=0.3608p pd=2.52u as=0.3608p ps=2.52u w=0.82u l=1u
X799 VDD.t21 a_1468_5863# a_1380_5960# VDD.t20 pfet_05v0 ad=0.5368p pd=3.32u as=0.5368p ps=3.32u w=1.22u l=1u
X800 VDD.t897 a_6732_8999# a_6644_9096# VDD.t896 pfet_05v0 ad=0.5368p pd=3.32u as=0.5368p ps=3.32u w=1.22u l=1u
X801 a_9420_10567# a_9332_10664# VSS VSS nfet_05v0 ad=0.3608p pd=2.52u as=0.3608p ps=2.52u w=0.82u l=1u
X802 VDD.t247 a_1468_2727# a_1380_2824# VDD.t246 pfet_05v0 ad=0.5368p pd=3.32u as=0.5368p ps=3.32u w=1.22u l=1u
X803 a_6844_14136# a_6756_14180# VSS VSS nfet_05v0 ad=0.3608p pd=2.52u as=0.3608p ps=2.52u w=0.82u l=1u
X804 a_20732_17272# a_20644_17316# VSS VSS nfet_05v0 ad=0.3608p pd=2.52u as=0.3608p ps=2.52u w=0.82u l=1u
X805 a_6844_11000# a_6756_11044# VSS VSS nfet_05v0 ad=0.3608p pd=2.52u as=0.3608p ps=2.52u w=0.82u l=1u
X806 a_1020_16839# a_932_16936# VSS VSS nfet_05v0 ad=0.3608p pd=2.52u as=0.3608p ps=2.52u w=0.82u l=1u
X807 VDD.t767 a_19500_15704# a_19412_15748# VDD.t766 pfet_05v0 ad=0.5368p pd=3.32u as=0.5368p ps=3.32u w=1.22u l=1u
X808 a_20896_13053# a_20603_12729# VDD.t950 VDD.t949 pfet_05v0 ad=0.352p pd=2.48u as=0.23p ps=1.54u w=0.8u l=0.5u
X809 VDD.t1876 a_10419_18100# uio_oe[0].t0 VDD.t1875 pfet_05v0 ad=0.5368p pd=3.32u as=0.5368p ps=3.32u w=1.22u l=0.5u
X810 a_2364_9432# a_2276_9476# VSS VSS nfet_05v0 ad=0.3608p pd=2.52u as=0.3608p ps=2.52u w=0.82u l=1u
X811 VSS a_20420_14180# avo[0].t3 VSS nfet_05v0 ad=0.3608p pd=2.52u as=0.2132p ps=1.34u w=0.82u l=0.6u
X812 a_2364_6296# a_2276_6340# VSS VSS nfet_05v0 ad=0.3608p pd=2.52u as=0.3608p ps=2.52u w=0.82u l=1u
X813 a_6284_8999# a_6196_9096# VSS VSS nfet_05v0 ad=0.3608p pd=2.52u as=0.3608p ps=2.52u w=0.82u l=1u
X814 a_15636_13855# dac_div_chain\[0\]_inv_notouch_.ZN a_14768_13443# VDD.t342 pfet_05v0 ad=54f pd=0.66u as=0.1872p ps=1.4u w=0.36u l=0.5u
X815 a_15200_13487# a_14664_13487# VSS VSS nfet_05v0 ad=43.2f pd=0.6u as=0.2637p ps=1.825u w=0.36u l=0.6u
X816 a_4940_2727# a_4852_2824# VSS VSS nfet_05v0 ad=0.3608p pd=2.52u as=0.3608p ps=2.52u w=0.82u l=1u
X817 VDD.t1291 a_15020_11000# a_14932_11044# VDD.t1002 pfet_05v0 ad=0.5368p pd=3.32u as=0.5368p ps=3.32u w=1.22u l=1u
X818 a_6284_5863# a_6196_5960# VSS VSS nfet_05v0 ad=0.3608p pd=2.52u as=0.3608p ps=2.52u w=0.82u l=1u
X819 VDD.t328 a_7292_6296# a_7204_6340# VDD.t327 pfet_05v0 ad=0.5368p pd=3.32u as=0.5368p ps=3.32u w=1.22u l=1u
X820 VSS ana_div_chain\[4\]_inv_notouch_.I ana_div_chain\[4\]_inv_notouch_.ZN VSS nfet_05v0 ad=0.3608p pd=2.52u as=0.3608p ps=2.52u w=0.82u l=0.6u
X821 VDD.t1950 a_7292_3160# a_7204_3204# VDD.t1949 pfet_05v0 ad=0.5368p pd=3.32u as=0.5368p ps=3.32u w=1.22u l=1u
X822 a_19052_10567# a_18964_10664# VSS VSS nfet_05v0 ad=0.3608p pd=2.52u as=0.3608p ps=2.52u w=0.82u l=1u
X823 a_19276_18407# a_19188_18504# VSS VSS nfet_05v0 ad=0.3608p pd=2.52u as=0.3608p ps=2.52u w=0.82u l=1u
X824 dac_div_chain\[0\]_inv_notouch_.ZN dac_div_chain\[1\]_dff_notouch_.CLK VDD.t1586 VDD.t1585 pfet_05v0 ad=0.5368p pd=3.32u as=0.5368p ps=3.32u w=1.22u l=0.5u
X825 a_6732_15271# a_6644_15368# VSS VSS nfet_05v0 ad=0.3608p pd=2.52u as=0.3608p ps=2.52u w=0.82u l=1u
X826 VDD.t473 a_17596_14136# a_17508_14180# VDD.t472 pfet_05v0 ad=0.5368p pd=3.32u as=0.5368p ps=3.32u w=1.22u l=1u
X827 a_3708_15271# a_3620_15368# VSS VSS nfet_05v0 ad=0.3608p pd=2.52u as=0.3608p ps=2.52u w=0.82u l=1u
X828 a_5500_1592# a_5412_1636# VSS VSS nfet_05v0 ad=0.3608p pd=2.52u as=0.3608p ps=2.52u w=0.82u l=1u
X829 VDD.t199 a_14236_7864# a_14148_7908# VDD.t198 pfet_05v0 ad=0.5368p pd=3.32u as=0.5368p ps=3.32u w=1.22u l=1u
X830 a_6732_12135# a_6644_12232# VSS VSS nfet_05v0 ad=0.3608p pd=2.52u as=0.3608p ps=2.52u w=0.82u l=1u
X831 VDD.t1315 a_17596_11000# a_17508_11044# VDD.t1314 pfet_05v0 ad=0.5368p pd=3.32u as=0.5368p ps=3.32u w=1.22u l=1u
X832 VDD.t1263 a_11324_1159# a_11236_1256# VDD.t1262 pfet_05v0 ad=0.5368p pd=3.32u as=0.5368p ps=3.32u w=1.22u l=1u
X833 a_3708_12135# a_3620_12232# VSS VSS nfet_05v0 ad=0.3608p pd=2.52u as=0.3608p ps=2.52u w=0.82u l=1u
X834 a_17685_852# a_17565_808# a_16941_808# VSS nfet_05v0 ad=43.2f pd=0.6u as=0.369p ps=2.77u w=0.36u l=0.6u
X835 VDD.t995 a_7180_10567# a_7092_10664# VDD.t994 pfet_05v0 ad=0.5368p pd=3.32u as=0.5368p ps=3.32u w=1.22u l=1u
X836 VDD.t1383 a_8972_15271# a_8884_15368# VDD.t1382 pfet_05v0 ad=0.5368p pd=3.32u as=0.5368p ps=3.32u w=1.22u l=1u
X837 a_11660_8999# a_11572_9096# VSS VSS nfet_05v0 ad=0.3608p pd=2.52u as=0.3608p ps=2.52u w=0.82u l=1u
X838 VDD.t839 a_20284_9432# a_20196_9476# VDD.t838 pfet_05v0 ad=0.5368p pd=3.32u as=0.5368p ps=3.32u w=1.22u l=1u
X839 VDD.t1408 a_4156_10567# a_4068_10664# VDD.t1407 pfet_05v0 ad=0.5368p pd=3.32u as=0.5368p ps=3.32u w=1.22u l=1u
X840 a_11660_5863# a_11572_5960# VSS VSS nfet_05v0 ad=0.3608p pd=2.52u as=0.3608p ps=2.52u w=0.82u l=1u
X841 VSS a_1011_18100# a_1011_18100# VSS nfet_05v0 ad=0.3608p pd=2.52u as=0.3608p ps=2.52u w=0.82u l=0.6u
X842 a_15356_15704# a_15268_15748# VSS VSS nfet_05v0 ad=0.3608p pd=2.52u as=0.3608p ps=2.52u w=0.82u l=1u
X843 a_7628_2727# a_7540_2824# VSS VSS nfet_05v0 ad=0.3608p pd=2.52u as=0.3608p ps=2.52u w=0.82u l=1u
X844 a_14768_15423# a_14336_15368# VDD.t613 VDD.t612 pfet_05v0 ad=54f pd=0.66u as=0.4554p ps=3.25u w=0.36u l=0.5u
X845 VDD.t1514 a_2364_12568# a_2276_12612# VDD.t1513 pfet_05v0 ad=0.5368p pd=3.32u as=0.5368p ps=3.32u w=1.22u l=1u
X846 VDD.t1658 a_3708_9432# a_3620_9476# VDD.t1524 pfet_05v0 ad=0.5368p pd=3.32u as=0.5368p ps=3.32u w=1.22u l=1u
X847 VDD.t1011 a_9420_18407# a_9332_18504# VDD.t1010 pfet_05v0 ad=0.5368p pd=3.32u as=0.5368p ps=3.32u w=1.22u l=1u
X848 VDD.t821 a_2812_14136# a_2724_14180# VDD.t820 pfet_05v0 ad=0.5368p pd=3.32u as=0.5368p ps=3.32u w=1.22u l=1u
X849 VDD.t779 a_4156_8999# a_4068_9096# VDD.t778 pfet_05v0 ad=0.5368p pd=3.32u as=0.5368p ps=3.32u w=1.22u l=1u
X850 VDD.t1047 a_2812_11000# a_2724_11044# VDD.t629 pfet_05v0 ad=0.5368p pd=3.32u as=0.5368p ps=3.32u w=1.22u l=1u
X851 VDD.t773 a_1011_18100# uio_oe[7].t0 VDD.t772 pfet_05v0 ad=0.5368p pd=3.32u as=0.5368p ps=3.32u w=1.22u l=0.5u
X852 VDD.t126 a_21628_6296# a_21540_6340# VDD.t125 pfet_05v0 ad=0.5368p pd=3.32u as=0.5368p ps=3.32u w=1.22u l=1u
X853 VDD.t271 a_21628_3160# a_21540_3204# VDD.t270 pfet_05v0 ad=0.5368p pd=3.32u as=0.5368p ps=3.32u w=1.22u l=1u
X854 VDD.t1504 a_9980_12568# a_9892_12612# VDD.t1503 pfet_05v0 ad=0.5368p pd=3.32u as=0.5368p ps=3.32u w=1.22u l=1u
X855 a_19948_15704# a_19860_15748# VSS VSS nfet_05v0 ad=0.3608p pd=2.52u as=0.3608p ps=2.52u w=0.82u l=1u
X856 dac_div_chain\[4\]_dff_notouch_.Q a_13168_16189# VDD.t1486 VDD.t1485 pfet_05v0 ad=0.3172p pd=1.74u as=0.5368p ps=3.32u w=1.22u l=0.5u
X857 VDD.t350 a_8188_14136# a_8100_14180# VDD.t349 pfet_05v0 ad=0.5368p pd=3.32u as=0.5368p ps=3.32u w=1.22u l=1u
X858 a_15398_14516# input2.Z VSS VSS nfet_05v0 ad=0.3608p pd=2.52u as=0.2911p ps=1.53u w=0.82u l=0.6u
X859 a_2364_2727# a_2276_2824# VSS VSS nfet_05v0 ad=0.3608p pd=2.52u as=0.3608p ps=2.52u w=0.82u l=1u
X860 VDD.t1944 a_1468_4728# a_1380_4772# VDD.t36 pfet_05v0 ad=0.5368p pd=3.32u as=0.5368p ps=3.32u w=1.22u l=1u
X861 a_6844_9432# a_6756_9476# VSS VSS nfet_05v0 ad=0.3608p pd=2.52u as=0.3608p ps=2.52u w=0.82u l=1u
X862 VDD.t298 a_1468_1592# a_1380_1636# VDD.t297 pfet_05v0 ad=0.5368p pd=3.32u as=0.5368p ps=3.32u w=1.22u l=1u
X863 a_12892_1159# a_12804_1256# VSS VSS nfet_05v0 ad=0.3608p pd=2.52u as=0.3608p ps=2.52u w=0.82u l=1u
X864 a_6844_6296# a_6756_6340# VSS VSS nfet_05v0 ad=0.3608p pd=2.52u as=0.3608p ps=2.52u w=0.82u l=1u
X865 a_7740_17272# a_7652_17316# VSS VSS nfet_05v0 ad=0.3608p pd=2.52u as=0.3608p ps=2.52u w=0.82u l=1u
X866 a_11324_14136# a_11236_14180# VSS VSS nfet_05v0 ad=0.3608p pd=2.52u as=0.3608p ps=2.52u w=0.82u l=1u
X867 a_11424_11115# a_11012_11528# VSS VSS nfet_05v0 ad=0.1782p pd=1.69u as=0.1053p ps=0.925u w=0.405u l=0.6u
X868 a_21829_852# a_21709_808# a_21085_808# VSS nfet_05v0 ad=43.2f pd=0.6u as=0.369p ps=2.77u w=0.36u l=0.6u
X869 a_5836_7431# a_5748_7528# VSS VSS nfet_05v0 ad=0.3608p pd=2.52u as=0.3608p ps=2.52u w=0.82u l=1u
X870 VDD.t33 a_8972_4295# a_8884_4392# VDD.t32 pfet_05v0 ad=0.5368p pd=3.32u as=0.5368p ps=3.32u w=1.22u l=1u
X871 a_10204_15704# a_10116_15748# VSS VSS nfet_05v0 ad=0.3608p pd=2.52u as=0.3608p ps=2.52u w=0.82u l=1u
X872 a_5388_13703# a_5300_13800# VSS VSS nfet_05v0 ad=0.3608p pd=2.52u as=0.3608p ps=2.52u w=0.82u l=1u
X873 a_3708_4295# a_3620_4392# VSS VSS nfet_05v0 ad=0.3608p pd=2.52u as=0.3608p ps=2.52u w=0.82u l=1u
X874 a_11548_1592# a_11460_1636# VSS VSS nfet_05v0 ad=0.3608p pd=2.52u as=0.3608p ps=2.52u w=0.82u l=1u
X875 VSS dac_div_chain\[2\]_load_slew15.Z a_7764_11911# VSS nfet_05v0 ad=0.1053p pd=0.925u as=0.1782p ps=1.69u w=0.405u l=0.6u
X876 VDD.t775 a_5388_8999# a_5300_9096# VDD.t774 pfet_05v0 ad=0.5368p pd=3.32u as=0.5368p ps=3.32u w=1.22u l=1u
X877 VDD.t277 a_18492_9432# a_18404_9476# VDD.t276 pfet_05v0 ad=0.5368p pd=3.32u as=0.5368p ps=3.32u w=1.22u l=1u
X878 a_11212_15271# a_11124_15368# VSS VSS nfet_05v0 ad=0.3608p pd=2.52u as=0.3608p ps=2.52u w=0.82u l=1u
X879 a_17260_4295# a_17172_4392# VSS VSS nfet_05v0 ad=0.3608p pd=2.52u as=0.3608p ps=2.52u w=0.82u l=1u
X880 a_14432_11875# ana_div_chain\[1\]_dff_notouch_.CLK VSS VSS nfet_05v0 ad=0.1782p pd=1.69u as=0.1053p ps=0.925u w=0.405u l=0.6u
X881 VDD.t1494 a_12240_16189# a_12212_15865# VDD.t1493 pfet_05v0 ad=0.1044p pd=0.94u as=43.2f ps=0.6u w=0.36u l=0.5u
X882 a_18940_14136# a_18852_14180# VSS VSS nfet_05v0 ad=0.3608p pd=2.52u as=0.3608p ps=2.52u w=0.82u l=1u
X883 a_16700_7864# a_16612_7908# VSS VSS nfet_05v0 ad=0.3608p pd=2.52u as=0.3608p ps=2.52u w=0.82u l=1u
X884 a_17252_16991# a_15940_16615# a_16908_16623# VDD.t988 pfet_05v0 ad=43.2f pd=0.6u as=0.1872p ps=1.4u w=0.36u l=0.5u
X885 a_10971_13855# a_9408_13800# a_10336_13443# VSS nfet_05v0 ad=93.59999f pd=0.88u as=93.59999f ps=0.88u w=0.36u l=0.6u
X886 a_16700_4728# a_16612_4772# VSS VSS nfet_05v0 ad=0.3608p pd=2.52u as=0.3608p ps=2.52u w=0.82u l=1u
X887 ana_div_chain\[2\]_dff_notouch_.Q a_13280_11485# VDD.t444 VDD.t443 pfet_05v0 ad=0.3172p pd=1.74u as=0.5368p ps=3.32u w=1.22u l=0.5u
X888 a_18940_11000# a_18852_11044# VSS VSS nfet_05v0 ad=0.3608p pd=2.52u as=0.3608p ps=2.52u w=0.82u l=1u
X889 a_15916_11000# a_15828_11044# VSS VSS nfet_05v0 ad=0.3608p pd=2.52u as=0.3608p ps=2.52u w=0.82u l=1u
X890 a_17148_12568# a_17060_12612# VSS VSS nfet_05v0 ad=0.3608p pd=2.52u as=0.3608p ps=2.52u w=0.82u l=1u
X891 VDD.t1112 a_15020_16839# a_14932_16936# VDD.t1111 pfet_05v0 ad=0.5368p pd=3.32u as=0.5368p ps=3.32u w=1.22u l=1u
X892 VDD.t858 a_13340_6296# a_13252_6340# VDD.t857 pfet_05v0 ad=0.5368p pd=3.32u as=0.5368p ps=3.32u w=1.22u l=1u
X893 VDD.t501 a_13340_3160# a_13252_3204# VDD.t500 pfet_05v0 ad=0.5368p pd=3.32u as=0.5368p ps=3.32u w=1.22u l=1u
X894 VDD.t654 a_10764_8999# a_10676_9096# VDD.t653 pfet_05v0 ad=0.5368p pd=3.32u as=0.5368p ps=3.32u w=1.22u l=1u
X895 VDD.t228 a_13788_1159# a_13700_1256# VDD.t227 pfet_05v0 ad=0.5368p pd=3.32u as=0.5368p ps=3.32u w=1.22u l=1u
X896 dvo[0].t0 a_15398_14516# VSS VSS nfet_05v0 ad=0.2132p pd=1.34u as=0.3608p ps=2.52u w=0.82u l=0.6u
X897 a_2812_3160# a_2724_3204# VSS VSS nfet_05v0 ad=0.3608p pd=2.52u as=0.3608p ps=2.52u w=0.82u l=1u
X898 VDD.t382 a_19836_6296# a_19748_6340# VDD.t381 pfet_05v0 ad=0.5368p pd=3.32u as=0.5368p ps=3.32u w=1.22u l=1u
X899 VDD.t1805 a_19836_3160# a_19748_3204# VDD.t1804 pfet_05v0 ad=0.5368p pd=3.32u as=0.5368p ps=3.32u w=1.22u l=1u
X900 a_15180_13855# a_14664_13487# VDD.t618 VDD.t617 pfet_05v0 ad=43.2f pd=0.6u as=0.1044p ps=0.94u w=0.36u l=0.5u
X901 a_4156_1592# a_4068_1636# VSS VSS nfet_05v0 ad=0.3608p pd=2.52u as=0.3608p ps=2.52u w=0.82u l=1u
X902 a_14684_7864# a_14596_7908# VSS VSS nfet_05v0 ad=0.3608p pd=2.52u as=0.3608p ps=2.52u w=0.82u l=1u
X903 a_14684_4728# a_14596_4772# VSS VSS nfet_05v0 ad=0.3608p pd=2.52u as=0.3608p ps=2.52u w=0.82u l=1u
X904 a_13052_12729# a_12536_13097# VDD.t210 VDD.t209 pfet_05v0 ad=43.2f pd=0.6u as=0.1044p ps=0.94u w=0.36u l=0.5u
X905 a_22076_3160# a_21988_3204# VSS VSS nfet_05v0 ad=0.3608p pd=2.52u as=0.3608p ps=2.52u w=0.82u l=1u
X906 VDD.t120 a_5948_4728# a_5860_4772# VDD.t119 pfet_05v0 ad=0.5368p pd=3.32u as=0.5368p ps=3.32u w=1.22u l=1u
X907 VDD.t2104 a_16028_6296# a_15940_6340# VDD.t2103 pfet_05v0 ad=0.5368p pd=3.32u as=0.5368p ps=3.32u w=1.22u l=1u
X908 VDD.t491 a_16028_3160# a_15940_3204# VDD.t490 pfet_05v0 ad=0.5368p pd=3.32u as=0.5368p ps=3.32u w=1.22u l=1u
X909 VDD.t1861 a_5948_1592# a_5860_1636# VDD.t1860 pfet_05v0 ad=0.5368p pd=3.32u as=0.5368p ps=3.32u w=1.22u l=1u
X910 a_1020_9432# a_932_9476# VSS VSS nfet_05v0 ad=0.3608p pd=2.52u as=0.3608p ps=2.52u w=0.82u l=1u
X911 a_3260_13703# a_3172_13800# VSS VSS nfet_05v0 ad=0.3608p pd=2.52u as=0.3608p ps=2.52u w=0.82u l=1u
X912 VDD.t1755 a_16700_7864# a_16612_7908# VDD.t1754 pfet_05v0 ad=0.5368p pd=3.32u as=0.5368p ps=3.32u w=1.22u l=1u
X913 VDD.t1448 a_13228_10567# a_13140_10664# VDD.t1447 pfet_05v0 ad=0.5368p pd=3.32u as=0.5368p ps=3.32u w=1.22u l=1u
X914 a_11772_14136# a_11684_14180# VSS VSS nfet_05v0 ad=0.3608p pd=2.52u as=0.3608p ps=2.52u w=0.82u l=1u
X915 a_1020_6296# a_932_6340# VSS VSS nfet_05v0 ad=0.3608p pd=2.52u as=0.3608p ps=2.52u w=0.82u l=1u
X916 VDD.t805 a_12352_11485# a_12324_11161# VDD.t804 pfet_05v0 ad=0.1044p pd=0.94u as=43.2f ps=0.6u w=0.36u l=0.5u
X917 a_6396_15704# a_6308_15748# VSS VSS nfet_05v0 ad=0.3608p pd=2.52u as=0.3608p ps=2.52u w=0.82u l=1u
X918 VDD.t1036 a_13228_4295# a_13140_4392# VDD.t1035 pfet_05v0 ad=0.5368p pd=3.32u as=0.5368p ps=3.32u w=1.22u l=1u
X919 VDD.t1562 a_20662_13352# avo[1].t3 VDD.t1561 pfet_05v0 ad=0.3782p pd=1.84u as=0.5368p ps=3.32u w=1.22u l=0.5u
X920 VDD.t819 a_2812_16839# a_2724_16936# VDD.t818 pfet_05v0 ad=0.5368p pd=3.32u as=0.5368p ps=3.32u w=1.22u l=1u
X921 VDD.t658 a_9868_8999# a_9780_9096# VDD.t657 pfet_05v0 ad=0.5368p pd=3.32u as=0.5368p ps=3.32u w=1.22u l=1u
X922 a_11660_15271# a_11572_15368# VSS VSS nfet_05v0 ad=0.3608p pd=2.52u as=0.3608p ps=2.52u w=0.82u l=1u
X923 a_7292_7864# a_7204_7908# VSS VSS nfet_05v0 ad=0.3608p pd=2.52u as=0.3608p ps=2.52u w=0.82u l=1u
X924 a_7292_4728# a_7204_4772# VSS VSS nfet_05v0 ad=0.3608p pd=2.52u as=0.3608p ps=2.52u w=0.82u l=1u
X925 VDD.t2098 a_14684_7864# a_14596_7908# VDD.t2097 pfet_05v0 ad=0.5368p pd=3.32u as=0.5368p ps=3.32u w=1.22u l=1u
X926 a_15916_10567# a_15828_10664# VSS VSS nfet_05v0 ad=0.3608p pd=2.52u as=0.3608p ps=2.52u w=0.82u l=1u
X927 a_8176_12232# a_7764_11911# VSS VSS nfet_05v0 ad=0.1782p pd=1.69u as=0.1053p ps=0.925u w=0.405u l=0.6u
X928 a_6284_16839# a_6196_16936# VSS VSS nfet_05v0 ad=0.3608p pd=2.52u as=0.3608p ps=2.52u w=0.82u l=1u
X929 VDD.t744 a_11772_1159# a_11684_1256# VDD.t743 pfet_05v0 ad=0.5368p pd=3.32u as=0.5368p ps=3.32u w=1.22u l=1u
X930 avo[4].t3 a_16612_17316# VDD.t1704 VDD.t1703 pfet_05v0 ad=0.3782p pd=1.84u as=0.4941p ps=2.03u w=1.22u l=0.5u
X931 a_16812_8999# a_16724_9096# VSS VSS nfet_05v0 ad=0.3608p pd=2.52u as=0.3608p ps=2.52u w=0.82u l=1u
X932 a_9420_15271# a_9332_15368# VSS VSS nfet_05v0 ad=0.3608p pd=2.52u as=0.3608p ps=2.52u w=0.82u l=1u
X933 a_16812_5863# a_16724_5960# VSS VSS nfet_05v0 ad=0.3608p pd=2.52u as=0.3608p ps=2.52u w=0.82u l=1u
X934 a_17596_12568# a_17508_12612# VSS VSS nfet_05v0 ad=0.3608p pd=2.52u as=0.3608p ps=2.52u w=0.82u l=1u
X935 a_20662_13352# ana_div_chain\[0\]_dff_notouch_.Q VDD.t236 VDD.t235 pfet_05v0 ad=0.5368p pd=3.32u as=0.4941p ps=2.03u w=1.22u l=0.5u
X936 a_11216_13487# a_8996_13479# a_10971_13855# VSS nfet_05v0 ad=43.2f pd=0.6u as=93.59999f ps=0.88u w=0.36u l=0.6u
X937 a_2364_14136# a_2276_14180# VSS VSS nfet_05v0 ad=0.3608p pd=2.52u as=0.3608p ps=2.52u w=0.82u l=1u
X938 a_19920_13097# a_19040_12683# a_19596_13097# VSS nfet_05v0 ad=43.2f pd=0.6u as=0.207p ps=1.51u w=0.36u l=0.6u
X939 VDD.t671 a_12192_13053# a_12152_12637# VDD.t670 pfet_05v0 ad=0.2249p pd=1.385u as=0.3806p ps=2.61u w=0.865u l=0.5u
X940 VDD.t1872 a_11324_18407# a_11236_18504# VDD.t1871 pfet_05v0 ad=0.5368p pd=3.32u as=0.5368p ps=3.32u w=1.22u l=1u
X941 a_2364_11000# a_2276_11044# VSS VSS nfet_05v0 ad=0.3608p pd=2.52u as=0.3608p ps=2.52u w=0.82u l=1u
X942 VDD.t1231 a_5052_12568# a_4964_12612# VDD.t1230 pfet_05v0 ad=0.5368p pd=3.32u as=0.5368p ps=3.32u w=1.22u l=1u
X943 VDD.t845 a_6844_17272# a_6756_17316# VDD.t844 pfet_05v0 ad=0.5368p pd=3.32u as=0.5368p ps=3.32u w=1.22u l=1u
X944 VSS dvo[5].t6 a_11796_16577# VSS nfet_05v0 ad=0.153p pd=1.195u as=0.1584p ps=1.6u w=0.36u l=0.6u
X945 VDD.t700 a_11212_4295# a_11124_4392# VDD.t699 pfet_05v0 ad=0.5368p pd=3.32u as=0.5368p ps=3.32u w=1.22u l=1u
X946 VDD.t1394 a_7292_7864# a_7204_7908# VDD.t1393 pfet_05v0 ad=0.5368p pd=3.32u as=0.5368p ps=3.32u w=1.22u l=1u
X947 a_2812_12568# a_2724_12612# VSS VSS nfet_05v0 ad=0.3608p pd=2.52u as=0.3608p ps=2.52u w=0.82u l=1u
X948 a_1020_2727# a_932_2824# VSS VSS nfet_05v0 ad=0.3608p pd=2.52u as=0.3608p ps=2.52u w=0.82u l=1u
X949 VDD.t572 a_5500_14136# a_5412_14180# VDD.t571 pfet_05v0 ad=0.5368p pd=3.32u as=0.5368p ps=3.32u w=1.22u l=1u
X950 a_21628_7864# a_21540_7908# VSS VSS nfet_05v0 ad=0.3608p pd=2.52u as=0.3608p ps=2.52u w=0.82u l=1u
X951 a_5500_9432# a_5412_9476# VSS VSS nfet_05v0 ad=0.3608p pd=2.52u as=0.3608p ps=2.52u w=0.82u l=1u
X952 a_19052_12135# a_18964_12232# VSS VSS nfet_05v0 ad=0.3608p pd=2.52u as=0.3608p ps=2.52u w=0.82u l=1u
X953 a_16908_16623# ana_div_chain\[4\]_inv_notouch_.ZN a_16784_16991# VDD.t1709 pfet_05v0 ad=0.1872p pd=1.4u as=54f ps=0.66u w=0.36u l=0.5u
X954 a_9420_8999# a_9332_9096# VSS VSS nfet_05v0 ad=0.3608p pd=2.52u as=0.3608p ps=2.52u w=0.82u l=1u
X955 VDD.t1446 a_13676_10567# a_13588_10664# VDD.t1445 pfet_05v0 ad=0.5368p pd=3.32u as=0.5368p ps=3.32u w=1.22u l=1u
X956 a_21628_4728# a_21540_4772# VSS VSS nfet_05v0 ad=0.3608p pd=2.52u as=0.3608p ps=2.52u w=0.82u l=1u
X957 a_5500_6296# a_5412_6340# VSS VSS nfet_05v0 ad=0.3608p pd=2.52u as=0.3608p ps=2.52u w=0.82u l=1u
X958 VDD.t396 a_5500_11000# a_5412_11044# VDD.t395 pfet_05v0 ad=0.5368p pd=3.32u as=0.5368p ps=3.32u w=1.22u l=1u
X959 VSS a_18208_16579# a_18160_16623# VSS nfet_05v0 ad=0.142p pd=1.14u as=43.2f ps=0.6u w=0.36u l=0.6u
X960 a_9420_5863# a_9332_5960# VSS VSS nfet_05v0 ad=0.3608p pd=2.52u as=0.3608p ps=2.52u w=0.82u l=1u
X961 VDD.t610 a_15264_15011# a_15236_15423# VDD.t609 pfet_05v0 ad=0.1044p pd=0.94u as=43.2f ps=0.6u w=0.36u l=0.5u
X962 VDD.t1186 a_17708_4295# a_17620_4392# VDD.t1185 pfet_05v0 ad=0.5368p pd=3.32u as=0.5368p ps=3.32u w=1.22u l=1u
X963 a_19968_13053# a_19596_13097# VSS VSS nfet_05v0 ad=93.59999f pd=0.88u as=0.2637p ps=1.825u w=0.36u l=0.6u
X964 a_10024_12287# a_8176_12232# a_9739_12287# VDD.t1535 pfet_05v0 ad=50.4f pd=0.64u as=0.1665p ps=1.285u w=0.36u l=0.5u
X965 VSS a_17862_17744# avo[5].t2 VSS nfet_05v0 ad=0.2911p pd=1.53u as=0.2132p ps=1.34u w=0.82u l=0.6u
X966 a_14272_13487# a_13272_13352# VSS VSS nfet_05v0 ad=43.2f pd=0.6u as=0.142p ps=1.14u w=0.36u l=0.6u
X967 a_12304_11529# a_11424_11115# a_11980_11529# VSS nfet_05v0 ad=43.2f pd=0.6u as=0.207p ps=1.51u w=0.36u l=0.6u
X968 a_11748_12568# a_12192_13053# a_12144_13097# VSS nfet_05v0 ad=93.59999f pd=0.88u as=43.2f ps=0.6u w=0.36u l=0.6u
X969 a_9980_11000# a_9892_11044# VSS VSS nfet_05v0 ad=0.3608p pd=2.52u as=0.3608p ps=2.52u w=0.82u l=1u
X970 dac_div_chain\[2\]_dff_notouch_.D dac_div_chain\[2\]_load_slew11.Z VSS VSS nfet_05v0 ad=0.3608p pd=2.52u as=0.3608p ps=2.52u w=0.82u l=0.6u
X971 VDD.t1847 a_1468_15271# a_1380_15368# VDD.t1714 pfet_05v0 ad=0.5368p pd=3.32u as=0.5368p ps=3.32u w=1.22u l=1u
X972 a_1468_3160# a_1380_3204# VSS VSS nfet_05v0 ad=0.3608p pd=2.52u as=0.3608p ps=2.52u w=0.82u l=1u
X973 a_10204_1592# a_10116_1636# VSS VSS nfet_05v0 ad=0.3608p pd=2.52u as=0.3608p ps=2.52u w=0.82u l=1u
X974 VDD.t720 a_7068_1159# a_6980_1256# VDD.t719 pfet_05v0 ad=0.5368p pd=3.32u as=0.5368p ps=3.32u w=1.22u l=1u
X975 a_8860_15704# a_8772_15748# VSS VSS nfet_05v0 ad=0.3608p pd=2.52u as=0.3608p ps=2.52u w=0.82u l=1u
X976 VDD.t75 a_5836_5863# a_5748_5960# VDD.t74 pfet_05v0 ad=0.5368p pd=3.32u as=0.5368p ps=3.32u w=1.22u l=1u
X977 VSS a_13384_11784# wire18.I VSS nfet_05v0 ad=0.3608p pd=2.52u as=0.2132p ps=1.34u w=0.82u l=0.6u
X978 VDD.t1221 a_5836_2727# a_5748_2824# VDD.t1220 pfet_05v0 ad=0.5368p pd=3.32u as=0.5368p ps=3.32u w=1.22u l=1u
X979 VDD.t1467 a_2812_15704# a_2724_15748# VDD.t961 pfet_05v0 ad=0.5368p pd=3.32u as=0.5368p ps=3.32u w=1.22u l=1u
X980 VDD.t1790 a_2812_7431# a_2724_7528# VDD.t1734 pfet_05v0 ad=0.5368p pd=3.32u as=0.5368p ps=3.32u w=1.22u l=1u
X981 a_11996_1592# a_11908_1636# VSS VSS nfet_05v0 ad=0.3608p pd=2.52u as=0.3608p ps=2.52u w=0.82u l=1u
X982 VDD.t49 a_21628_7864# a_21540_7908# VDD.t48 pfet_05v0 ad=0.5368p pd=3.32u as=0.5368p ps=3.32u w=1.22u l=1u
X983 ana_div_chain\[2\]_dff_notouch_.CLK a_10340_13143# VDD.t1502 VDD.t1501 pfet_05v0 ad=0.5368p pd=3.32u as=0.4015p ps=1.92u w=1.22u l=0.5u
X984 a_8076_13703# a_7988_13800# VSS VSS nfet_05v0 ad=0.3608p pd=2.52u as=0.3608p ps=2.52u w=0.82u l=1u
X985 VDD.t1706 a_16612_17316# avo[4].t4 VDD.t1705 pfet_05v0 ad=0.3782p pd=1.84u as=0.3782p ps=1.84u w=1.22u l=0.5u
X986 VDD.t154 a_12444_1159# a_12356_1256# VDD.t153 pfet_05v0 ad=0.5368p pd=3.32u as=0.5368p ps=3.32u w=1.22u l=1u
X987 a_2588_18407# a_2500_18504# VSS VSS nfet_05v0 ad=0.3608p pd=2.52u as=0.3608p ps=2.52u w=0.82u l=1u
X988 a_2364_10567# a_2276_10664# VSS VSS nfet_05v0 ad=0.3608p pd=2.52u as=0.3608p ps=2.52u w=0.82u l=1u
X989 a_11772_1159# a_11684_1256# VSS VSS nfet_05v0 ad=0.3608p pd=2.52u as=0.3608p ps=2.52u w=0.82u l=1u
X990 a_12780_8999# a_12692_9096# VSS VSS nfet_05v0 ad=0.3608p pd=2.52u as=0.3608p ps=2.52u w=0.82u l=1u
X991 a_12780_5863# a_12692_5960# VSS VSS nfet_05v0 ad=0.3608p pd=2.52u as=0.3608p ps=2.52u w=0.82u l=1u
X992 VDD.t1092 a_8188_15704# a_8100_15748# VDD.t1091 pfet_05v0 ad=0.5368p pd=3.32u as=0.5368p ps=3.32u w=1.22u l=1u
X993 VDD.t1869 a_11772_18407# a_11684_18504# VDD.t1868 pfet_05v0 ad=0.5368p pd=3.32u as=0.5368p ps=3.32u w=1.22u l=1u
X994 VDD.t831 a_7628_16839# a_7540_16936# VDD.t830 pfet_05v0 ad=0.5368p pd=3.32u as=0.5368p ps=3.32u w=1.22u l=1u
X995 VDD.t1907 a_21180_4728# a_21092_4772# VDD.t1906 pfet_05v0 ad=0.5368p pd=3.32u as=0.5368p ps=3.32u w=1.22u l=1u
X996 VDD.t1616 a_15916_8999# a_15828_9096# VDD.t1615 pfet_05v0 ad=0.5368p pd=3.32u as=0.5368p ps=3.32u w=1.22u l=1u
X997 VDD.t1444 a_4940_13703# a_4852_13800# VDD.t1443 pfet_05v0 ad=0.5368p pd=3.32u as=0.5368p ps=3.32u w=1.22u l=1u
X998 VDD.t732 a_21180_1592# a_21092_1636# VDD.t731 pfet_05v0 ad=0.5368p pd=3.32u as=0.5368p ps=3.32u w=1.22u l=1u
X999 VSS a_8902_13040# dvo[2].t3 VSS nfet_05v0 ad=0.2132p pd=1.34u as=0.3608p ps=2.52u w=0.82u l=0.6u
X1000 VDD.t922 a_1916_13703# a_1828_13800# VDD.t824 pfet_05v0 ad=0.5368p pd=3.32u as=0.5368p ps=3.32u w=1.22u l=1u
X1001 a_13340_7864# a_13252_7908# VSS VSS nfet_05v0 ad=0.3608p pd=2.52u as=0.3608p ps=2.52u w=0.82u l=1u
X1002 a_13340_4728# a_13252_4772# VSS VSS nfet_05v0 ad=0.3608p pd=2.52u as=0.3608p ps=2.52u w=0.82u l=1u
X1003 VDD.t89 a_4604_4728# a_4516_4772# VDD.t88 pfet_05v0 ad=0.5368p pd=3.32u as=0.5368p ps=3.32u w=1.22u l=1u
X1004 VDD.t1096 a_6508_18407# a_6420_18504# VDD.t1095 pfet_05v0 ad=0.5368p pd=3.32u as=0.5368p ps=3.32u w=1.22u l=1u
X1005 a_3260_17272# a_3172_17316# VSS VSS nfet_05v0 ad=0.3608p pd=2.52u as=0.3608p ps=2.52u w=0.82u l=1u
X1006 a_9308_1592# a_9220_1636# VSS VSS nfet_05v0 ad=0.3608p pd=2.52u as=0.3608p ps=2.52u w=0.82u l=1u
X1007 VDD.t1814 a_4604_1592# a_4516_1636# VDD.t1813 pfet_05v0 ad=0.5368p pd=3.32u as=0.5368p ps=3.32u w=1.22u l=1u
X1008 VDD.t588 a_12108_8999# a_12020_9096# VDD.t587 pfet_05v0 ad=0.5368p pd=3.32u as=0.5368p ps=3.32u w=1.22u l=1u
X1009 VDD.t1743 a_19052_7431# a_18964_7528# VDD.t1742 pfet_05v0 ad=0.5368p pd=3.32u as=0.5368p ps=3.32u w=1.22u l=1u
X1010 a_19836_7864# a_19748_7908# VSS VSS nfet_05v0 ad=0.3608p pd=2.52u as=0.3608p ps=2.52u w=0.82u l=1u
X1011 VSS a_3139_18100# a_3139_18100# VSS nfet_05v0 ad=0.3608p pd=2.52u as=0.3608p ps=2.52u w=0.82u l=0.6u
X1012 a_19836_4728# a_19748_4772# VSS VSS nfet_05v0 ad=0.3608p pd=2.52u as=0.3608p ps=2.52u w=0.82u l=1u
X1013 a_11548_6296# a_11460_6340# VSS VSS nfet_05v0 ad=0.3608p pd=2.52u as=0.3608p ps=2.52u w=0.82u l=1u
X1014 a_15468_8999# a_15380_9096# VSS VSS nfet_05v0 ad=0.3608p pd=2.52u as=0.3608p ps=2.52u w=0.82u l=1u
X1015 a_15468_5863# a_15380_5960# VSS VSS nfet_05v0 ad=0.3608p pd=2.52u as=0.3608p ps=2.52u w=0.82u l=1u
X1016 a_8902_13040# dac_div_chain\[1\]_inv_notouch_.I VSS VSS nfet_05v0 ad=0.3608p pd=2.52u as=0.2911p ps=1.53u w=0.82u l=0.6u
X1017 VSS a_10032_11875# a_9984_11919# VSS nfet_05v0 ad=0.142p pd=1.14u as=43.2f ps=0.6u w=0.36u l=0.6u
X1018 a_16028_7864# a_15940_7908# VSS VSS nfet_05v0 ad=0.3608p pd=2.52u as=0.3608p ps=2.52u w=0.82u l=1u
X1019 a_5948_3160# a_5860_3204# VSS VSS nfet_05v0 ad=0.3608p pd=2.52u as=0.3608p ps=2.52u w=0.82u l=1u
X1020 VDD.t19 a_13676_4295# a_13588_4392# VDD.t18 pfet_05v0 ad=0.5368p pd=3.32u as=0.5368p ps=3.32u w=1.22u l=1u
X1021 a_16028_4728# a_15940_4772# VSS VSS nfet_05v0 ad=0.3608p pd=2.52u as=0.3608p ps=2.52u w=0.82u l=1u
X1022 VDD.t1354 a_8524_8999# a_8436_9096# VDD.t1353 pfet_05v0 ad=0.5368p pd=3.32u as=0.5368p ps=3.32u w=1.22u l=1u
X1023 a_14236_18407# a_14148_18504# VSS VSS nfet_05v0 ad=0.3608p pd=2.52u as=0.3608p ps=2.52u w=0.82u l=1u
X1024 a_10316_2727# a_10228_2824# VSS VSS nfet_05v0 ad=0.3608p pd=2.52u as=0.3608p ps=2.52u w=0.82u l=1u
X1025 a_7964_1159# a_7876_1256# VSS VSS nfet_05v0 ad=0.3608p pd=2.52u as=0.3608p ps=2.52u w=0.82u l=1u
X1026 a_9408_13800# a_8996_13479# VDD.t1058 VDD.t1057 pfet_05v0 ad=0.3806p pd=2.61u as=0.2249p ps=1.385u w=0.865u l=0.5u
X1027 a_15580_1159# a_15492_1256# VSS VSS nfet_05v0 ad=0.3608p pd=2.52u as=0.3608p ps=2.52u w=0.82u l=1u
X1028 VDD.t338 a_13340_7864# a_13252_7908# VDD.t337 pfet_05v0 ad=0.5368p pd=3.32u as=0.5368p ps=3.32u w=1.22u l=1u
X1029 VDD.t1377 a_18940_17272# a_18852_17316# VDD.t1376 pfet_05v0 ad=0.5368p pd=3.32u as=0.5368p ps=3.32u w=1.22u l=1u
X1030 a_4156_9432# a_4068_9476# VSS VSS nfet_05v0 ad=0.3608p pd=2.52u as=0.3608p ps=2.52u w=0.82u l=1u
X1031 VDD.t61 a_19836_7864# a_19748_7908# VDD.t60 pfet_05v0 ad=0.5368p pd=3.32u as=0.5368p ps=3.32u w=1.22u l=1u
X1032 a_8076_8999# a_7988_9096# VSS VSS nfet_05v0 ad=0.3608p pd=2.52u as=0.3608p ps=2.52u w=0.82u l=1u
X1033 a_19948_16839# a_19860_16936# VSS VSS nfet_05v0 ad=0.3608p pd=2.52u as=0.3608p ps=2.52u w=0.82u l=1u
X1034 a_4156_6296# a_4068_6340# VSS VSS nfet_05v0 ad=0.3608p pd=2.52u as=0.3608p ps=2.52u w=0.82u l=1u
X1035 a_6732_2727# a_6644_2824# VSS VSS nfet_05v0 ad=0.3608p pd=2.52u as=0.3608p ps=2.52u w=0.82u l=1u
X1036 a_8076_5863# a_7988_5960# VSS VSS nfet_05v0 ad=0.3608p pd=2.52u as=0.3608p ps=2.52u w=0.82u l=1u
X1037 a_12780_13703# a_12692_13800# VSS VSS nfet_05v0 ad=0.3608p pd=2.52u as=0.3608p ps=2.52u w=0.82u l=1u
X1038 VDD.t1323 a_2812_9432# a_2724_9476# VDD.t1322 pfet_05v0 ad=0.5368p pd=3.32u as=0.5368p ps=3.32u w=1.22u l=1u
X1039 VDD.t1212 a_1020_12135# a_932_12232# VDD.t1211 pfet_05v0 ad=0.5368p pd=3.32u as=0.5368p ps=3.32u w=1.22u l=1u
X1040 a_12352_11485# a_11980_11529# VSS VSS nfet_05v0 ad=93.59999f pd=0.88u as=0.2637p ps=1.825u w=0.36u l=0.6u
X1041 a_18604_10567# a_18516_10664# VSS VSS nfet_05v0 ad=0.3608p pd=2.52u as=0.3608p ps=2.52u w=0.82u l=1u
X1042 a_18828_18407# a_18740_18504# VSS VSS nfet_05v0 ad=0.3608p pd=2.52u as=0.3608p ps=2.52u w=0.82u l=1u
X1043 VDD.t77 a_6284_4295# a_6196_4392# VDD.t76 pfet_05v0 ad=0.5368p pd=3.32u as=0.5368p ps=3.32u w=1.22u l=1u
X1044 VDD.t1792 a_16028_7864# a_15940_7908# VDD.t1791 pfet_05v0 ad=0.5368p pd=3.32u as=0.5368p ps=3.32u w=1.22u l=1u
X1045 VDD.t1527 a_3260_8999# a_3172_9096# VDD.t1526 pfet_05v0 ad=0.5368p pd=3.32u as=0.5368p ps=3.32u w=1.22u l=1u
X1046 VDD.t2000 a_20732_6296# a_20644_6340# VDD.t1999 pfet_05v0 ad=0.5368p pd=3.32u as=0.5368p ps=3.32u w=1.22u l=1u
X1047 VDD.t1474 a_22076_9432# a_21988_9476# VDD.t1473 pfet_05v0 ad=0.5368p pd=3.32u as=0.5368p ps=3.32u w=1.22u l=1u
X1048 a_2364_1159# a_2276_1256# VSS VSS nfet_05v0 ad=0.3608p pd=2.52u as=0.3608p ps=2.52u w=0.82u l=1u
X1049 VDD.t296 a_20732_3160# a_20644_3204# VDD.t295 pfet_05v0 ad=0.5368p pd=3.32u as=0.5368p ps=3.32u w=1.22u l=1u
X1050 VDD.t218 a_6956_18407# a_6868_18504# VDD.t217 pfet_05v0 ad=0.5368p pd=3.32u as=0.5368p ps=3.32u w=1.22u l=1u
X1051 VDD.t1661 a_6732_10567# a_6644_10664# VDD.t1660 pfet_05v0 ad=0.5368p pd=3.32u as=0.5368p ps=3.32u w=1.22u l=1u
X1052 dvo[2].t4 a_8902_13040# VSS VSS nfet_05v0 ad=0.2132p pd=1.34u as=0.2132p ps=1.34u w=0.82u l=0.6u
X1053 a_9964_13487# dac_div_chain\[3\]_inv_notouch_.ZN a_9840_13855# VDD.t694 pfet_05v0 ad=0.1872p pd=1.4u as=54f ps=0.66u w=0.36u l=0.5u
X1054 VDD.t626 a_3708_10567# a_3620_10664# VDD.t625 pfet_05v0 ad=0.5368p pd=3.32u as=0.5368p ps=3.32u w=1.22u l=1u
X1055 VDD.t1919 a_1468_7431# a_1380_7528# VDD.t1740 pfet_05v0 ad=0.5368p pd=3.32u as=0.5368p ps=3.32u w=1.22u l=1u
X1056 a_19948_8999# a_19860_9096# VSS VSS nfet_05v0 ad=0.3608p pd=2.52u as=0.3608p ps=2.52u w=0.82u l=1u
X1057 a_14908_15704# a_14820_15748# VSS VSS nfet_05v0 ad=0.3608p pd=2.52u as=0.3608p ps=2.52u w=0.82u l=1u
X1058 a_5052_14136# a_4964_14180# VSS VSS nfet_05v0 ad=0.3608p pd=2.52u as=0.3608p ps=2.52u w=0.82u l=1u
X1059 VDD.t1918 a_11660_4295# a_11572_4392# VDD.t1917 pfet_05v0 ad=0.5368p pd=3.32u as=0.5368p ps=3.32u w=1.22u l=1u
X1060 a_19948_5863# a_19860_5960# VSS VSS nfet_05v0 ad=0.3608p pd=2.52u as=0.3608p ps=2.52u w=0.82u l=1u
X1061 VDD.t1515 a_1916_12568# a_1828_12612# VDD.t1207 pfet_05v0 ad=0.5368p pd=3.32u as=0.5368p ps=3.32u w=1.22u l=1u
X1062 VDD.t876 a_9532_1159# a_9444_1256# VDD.t875 pfet_05v0 ad=0.5368p pd=3.32u as=0.5368p ps=3.32u w=1.22u l=1u
X1063 a_5052_11000# a_4964_11044# VSS VSS nfet_05v0 ad=0.3608p pd=2.52u as=0.3608p ps=2.52u w=0.82u l=1u
X1064 a_17148_13703# a_17060_13800# VSS VSS nfet_05v0 ad=0.3608p pd=2.52u as=0.3608p ps=2.52u w=0.82u l=1u
X1065 a_14684_18407# a_14596_18504# VSS VSS nfet_05v0 ad=0.3608p pd=2.52u as=0.3608p ps=2.52u w=0.82u l=1u
X1066 a_5500_12568# a_5412_12612# VSS VSS nfet_05v0 ad=0.3608p pd=2.52u as=0.3608p ps=2.52u w=0.82u l=1u
X1067 VDD.t1994 a_17148_6296# a_17060_6340# VDD.t1993 pfet_05v0 ad=0.5368p pd=3.32u as=0.5368p ps=3.32u w=1.22u l=1u
X1068 a_4940_7431# a_4852_7528# VSS VSS nfet_05v0 ad=0.3608p pd=2.52u as=0.3608p ps=2.52u w=0.82u l=1u
X1069 VSS a_13876_13639# a_13272_13352# VSS nfet_05v0 ad=0.142p pd=1.14u as=0.176p ps=1.68u w=0.4u l=0.6u
X1070 VDD.t1307 a_16364_10567# a_16276_10664# VDD.t1306 pfet_05v0 ad=0.5368p pd=3.32u as=0.5368p ps=3.32u w=1.22u l=1u
X1071 VDD.t158 a_17148_3160# a_17060_3204# VDD.t157 pfet_05v0 ad=0.5368p pd=3.32u as=0.5368p ps=3.32u w=1.22u l=1u
X1072 a_2812_4295# a_2724_4392# VSS VSS nfet_05v0 ad=0.3608p pd=2.52u as=0.3608p ps=2.52u w=0.82u l=1u
X1073 a_10652_1592# a_10564_1636# VSS VSS nfet_05v0 ad=0.3608p pd=2.52u as=0.3608p ps=2.52u w=0.82u l=1u
X1074 a_4156_2727# a_4068_2824# VSS VSS nfet_05v0 ad=0.3608p pd=2.52u as=0.3608p ps=2.52u w=0.82u l=1u
X1075 a_16700_18407# a_16612_18504# VSS VSS nfet_05v0 ad=0.3608p pd=2.52u as=0.3608p ps=2.52u w=0.82u l=1u
X1076 VDD.t1116 a_7180_15271# a_7092_15368# VDD.t1115 pfet_05v0 ad=0.5368p pd=3.32u as=0.5368p ps=3.32u w=1.22u l=1u
X1077 a_6172_1159# a_6084_1256# VSS VSS nfet_05v0 ad=0.3608p pd=2.52u as=0.3608p ps=2.52u w=0.82u l=1u
X1078 VSS a_19968_13053# a_19920_13097# VSS nfet_05v0 ad=0.2637p pd=1.825u as=43.2f ps=0.6u w=0.36u l=0.6u
X1079 VDD.t1028 a_4156_15271# a_4068_15368# VDD.t680 pfet_05v0 ad=0.5368p pd=3.32u as=0.5368p ps=3.32u w=1.22u l=1u
X1080 a_10288_13487# a_9408_13800# a_9964_13487# VSS nfet_05v0 ad=43.2f pd=0.6u as=0.207p ps=1.51u w=0.36u l=0.6u
X1081 a_7628_7431# a_7540_7528# VSS VSS nfet_05v0 ad=0.3608p pd=2.52u as=0.3608p ps=2.52u w=0.82u l=1u
X1082 VDD.t1384 a_2364_17272# a_2276_17316# VDD.t1213 pfet_05v0 ad=0.5368p pd=3.32u as=0.5368p ps=3.32u w=1.22u l=1u
X1083 VDD.t1076 a_5500_15704# a_5412_15748# VDD.t1075 pfet_05v0 ad=0.5368p pd=3.32u as=0.5368p ps=3.32u w=1.22u l=1u
X1084 a_19428_13097# a_18628_13096# VSS VSS nfet_05v0 ad=43.2f pd=0.6u as=0.1584p ps=1.6u w=0.36u l=0.6u
X1085 VDD.t339 a_12892_1159# a_12804_1256# VDD.t4 pfet_05v0 ad=0.5368p pd=3.32u as=0.5368p ps=3.32u w=1.22u l=1u
X1086 VDD.t1644 a_14708_12612# dvo[1].t4 VDD.t1643 pfet_05v0 ad=0.3782p pd=1.84u as=0.3782p ps=1.84u w=1.22u l=0.5u
X1087 VDD.t1576 a_1020_14136# a_932_14180# VDD.t1460 pfet_05v0 ad=0.5368p pd=3.32u as=0.5368p ps=3.32u w=1.22u l=1u
X1088 VDD.t1086 a_18940_6296# a_18852_6340# VDD.t1085 pfet_05v0 ad=0.5368p pd=3.32u as=0.5368p ps=3.32u w=1.22u l=1u
X1089 VDD.t1457 a_1020_11000# a_932_11044# VDD.t959 pfet_05v0 ad=0.5368p pd=3.32u as=0.5368p ps=3.32u w=1.22u l=1u
X1090 VDD.t185 a_18940_3160# a_18852_3204# VDD.t184 pfet_05v0 ad=0.5368p pd=3.32u as=0.5368p ps=3.32u w=1.22u l=1u
X1091 a_3260_1592# a_3172_1636# VSS VSS nfet_05v0 ad=0.3608p pd=2.52u as=0.3608p ps=2.52u w=0.82u l=1u
X1092 a_5276_18407# a_5188_18504# VSS VSS nfet_05v0 ad=0.3608p pd=2.52u as=0.3608p ps=2.52u w=0.82u l=1u
X1093 a_19052_4295# a_18964_4392# VSS VSS nfet_05v0 ad=0.3608p pd=2.52u as=0.3608p ps=2.52u w=0.82u l=1u
X1094 a_10204_9432# a_10116_9476# VSS VSS nfet_05v0 ad=0.3608p pd=2.52u as=0.3608p ps=2.52u w=0.82u l=1u
X1095 a_10204_6296# a_10116_6340# VSS VSS nfet_05v0 ad=0.3608p pd=2.52u as=0.3608p ps=2.52u w=0.82u l=1u
X1096 a_14124_8999# a_14036_9096# VSS VSS nfet_05v0 ad=0.3608p pd=2.52u as=0.3608p ps=2.52u w=0.82u l=1u
X1097 a_21180_3160# a_21092_3204# VSS VSS nfet_05v0 ad=0.3608p pd=2.52u as=0.3608p ps=2.52u w=0.82u l=1u
X1098 a_14124_5863# a_14036_5960# VSS VSS nfet_05v0 ad=0.3608p pd=2.52u as=0.3608p ps=2.52u w=0.82u l=1u
X1099 VDD.t862 a_15132_6296# a_15044_6340# VDD.t861 pfet_05v0 ad=0.5368p pd=3.32u as=0.5368p ps=3.32u w=1.22u l=1u
X1100 a_18156_15704# a_18068_15748# VSS VSS nfet_05v0 ad=0.3608p pd=2.52u as=0.3608p ps=2.52u w=0.82u l=1u
X1101 a_9756_1592# a_9668_1636# VSS VSS nfet_05v0 ad=0.3608p pd=2.52u as=0.3608p ps=2.52u w=0.82u l=1u
X1102 VDD.t1122 a_15132_3160# a_15044_3204# VDD.t1121 pfet_05v0 ad=0.5368p pd=3.32u as=0.5368p ps=3.32u w=1.22u l=1u
X1103 a_5388_2727# a_5300_2824# VSS VSS nfet_05v0 ad=0.3608p pd=2.52u as=0.3608p ps=2.52u w=0.82u l=1u
X1104 a_2364_7431# a_2276_7528# VSS VSS nfet_05v0 ad=0.3608p pd=2.52u as=0.3608p ps=2.52u w=0.82u l=1u
X1105 a_17596_13703# a_17508_13800# VSS VSS nfet_05v0 ad=0.3608p pd=2.52u as=0.3608p ps=2.52u w=0.82u l=1u
X1106 VDD.t811 a_1468_9432# a_1380_9476# VDD.t810 pfet_05v0 ad=0.5368p pd=3.32u as=0.5368p ps=3.32u w=1.22u l=1u
X1107 a_4604_3160# a_4516_3204# VSS VSS nfet_05v0 ad=0.3608p pd=2.52u as=0.3608p ps=2.52u w=0.82u l=1u
X1108 a_11996_6296# a_11908_6340# VSS VSS nfet_05v0 ad=0.3608p pd=2.52u as=0.3608p ps=2.52u w=0.82u l=1u
X1109 a_21709_808# ana_vco_in.t1 VDD.t827 VDD.t826 pfet_05v0 ad=0.3852p pd=2.86u as=0.1116p ps=0.98u w=0.36u l=0.5u
X1110 VDD.t1456 a_14012_17272# a_13924_17316# VDD.t1455 pfet_05v0 ad=0.5368p pd=3.32u as=0.5368p ps=3.32u w=1.22u l=1u
X1111 a_2364_15271# a_2276_15368# VSS VSS nfet_05v0 ad=0.3608p pd=2.52u as=0.3608p ps=2.52u w=0.82u l=1u
X1112 a_9868_18407# a_9780_18504# VSS VSS nfet_05v0 ad=0.3608p pd=2.52u as=0.3608p ps=2.52u w=0.82u l=1u
X1113 VDD.t1293 ana_div_chain\[4\]_dff_notouch_.CLK a_15940_16615# VDD.t1292 pfet_05v0 ad=0.2249p pd=1.385u as=0.3806p ps=2.61u w=0.865u l=0.5u
X1114 VDD.t1352 a_8972_8999# a_8884_9096# VDD.t1351 pfet_05v0 ad=0.5368p pd=3.32u as=0.5368p ps=3.32u w=1.22u l=1u
X1115 a_10764_2727# a_10676_2824# VSS VSS nfet_05v0 ad=0.3608p pd=2.52u as=0.3608p ps=2.52u w=0.82u l=1u
X1116 VDD.t358 a_18828_1159# a_18740_1256# VDD.t357 pfet_05v0 ad=0.5368p pd=3.32u as=0.5368p ps=3.32u w=1.22u l=1u
X1117 a_2364_12135# a_2276_12232# VSS VSS nfet_05v0 ad=0.3608p pd=2.52u as=0.3608p ps=2.52u w=0.82u l=1u
X1118 a_11980_11529# ana_div_chain\[2\]_inv_notouch_.ZN a_11812_11529# VSS nfet_05v0 ad=0.207p pd=1.51u as=43.2f ps=0.6u w=0.36u l=0.6u
X1119 a_2812_13703# a_2724_13800# VSS VSS nfet_05v0 ad=0.3608p pd=2.52u as=0.3608p ps=2.52u w=0.82u l=1u
X1120 a_9308_9432# a_9220_9476# VSS VSS nfet_05v0 ad=0.3608p pd=2.52u as=0.3608p ps=2.52u w=0.82u l=1u
X1121 VDD.t939 a_11366_10216# avo[2].t0 VDD.t938 pfet_05v0 ad=0.3782p pd=1.84u as=0.5368p ps=3.32u w=1.22u l=0.5u
X1122 a_5948_15704# a_5860_15748# VSS VSS nfet_05v0 ad=0.3608p pd=2.52u as=0.3608p ps=2.52u w=0.82u l=1u
X1123 a_9308_6296# a_9220_6340# VSS VSS nfet_05v0 ad=0.3608p pd=2.52u as=0.3608p ps=2.52u w=0.82u l=1u
X1124 a_7740_1592# a_7652_1636# VSS VSS nfet_05v0 ad=0.3608p pd=2.52u as=0.3608p ps=2.52u w=0.82u l=1u
X1125 a_1468_4295# a_1380_4392# VSS VSS nfet_05v0 ad=0.3608p pd=2.52u as=0.3608p ps=2.52u w=0.82u l=1u
X1126 a_18604_8999# a_18516_9096# VSS VSS nfet_05v0 ad=0.3608p pd=2.52u as=0.3608p ps=2.52u w=0.82u l=1u
X1127 a_5836_16839# a_5748_16936# VSS VSS nfet_05v0 ad=0.3608p pd=2.52u as=0.3608p ps=2.52u w=0.82u l=1u
X1128 a_18604_5863# a_18516_5960# VSS VSS nfet_05v0 ad=0.3608p pd=2.52u as=0.3608p ps=2.52u w=0.82u l=1u
X1129 a_11366_10216# wire18.I VDD.t1042 VDD.t1041 pfet_05v0 ad=0.5368p pd=3.32u as=0.4941p ps=2.03u w=1.22u l=0.5u
X1130 a_20732_7864# a_20644_7908# VSS VSS nfet_05v0 ad=0.3608p pd=2.52u as=0.3608p ps=2.52u w=0.82u l=1u
X1131 a_9868_2727# a_9780_2824# VSS VSS nfet_05v0 ad=0.3608p pd=2.52u as=0.3608p ps=2.52u w=0.82u l=1u
X1132 VDD.t622 a_19836_14136# a_19748_14180# VDD.t621 pfet_05v0 ad=0.5368p pd=3.32u as=0.5368p ps=3.32u w=1.22u l=1u
X1133 a_20732_4728# a_20644_4772# VSS VSS nfet_05v0 ad=0.3608p pd=2.52u as=0.3608p ps=2.52u w=0.82u l=1u
X1134 VDD.t691 a_5948_9432# a_5860_9476# VDD.t690 pfet_05v0 ad=0.5368p pd=3.32u as=0.5368p ps=3.32u w=1.22u l=1u
X1135 VDD.t546 a_19836_11000# a_19748_11044# VDD.t545 pfet_05v0 ad=0.5368p pd=3.32u as=0.5368p ps=3.32u w=1.22u l=1u
X1136 VDD.t1834 a_6284_12135# a_6196_12232# VDD.t1833 pfet_05v0 ad=0.5368p pd=3.32u as=0.5368p ps=3.32u w=1.22u l=1u
X1137 a_10336_13443# a_9964_13487# VSS VSS nfet_05v0 ad=93.59999f pd=0.88u as=0.2637p ps=1.825u w=0.36u l=0.6u
X1138 VDD.t265 a_16812_4295# a_16724_4392# VDD.t264 pfet_05v0 ad=0.5368p pd=3.32u as=0.5368p ps=3.32u w=1.22u l=1u
X1139 VDD.t1418 a_9420_10567# a_9332_10664# VDD.t1417 pfet_05v0 ad=0.5368p pd=3.32u as=0.5368p ps=3.32u w=1.22u l=1u
X1140 VDD.t1988 a_13228_15271# a_13140_15368# VDD.t1987 pfet_05v0 ad=0.5368p pd=3.32u as=0.5368p ps=3.32u w=1.22u l=1u
X1141 VDD.t458 a_16192_15011# ana_div_chain\[3\]_inv_notouch_.I VDD.t457 pfet_05v0 ad=0.854p pd=3.84u as=0.3172p ps=1.74u w=1.22u l=0.5u
X1142 VDD.t11 a_9980_1159# a_9892_1256# VDD.t10 pfet_05v0 ad=0.5368p pd=3.32u as=0.5368p ps=3.32u w=1.22u l=1u
X1143 a_21180_11000# a_21092_11044# VSS VSS nfet_05v0 ad=0.3608p pd=2.52u as=0.3608p ps=2.52u w=0.82u l=1u
X1144 VSS a_13280_11485# a_13232_11529# VSS nfet_05v0 ad=0.142p pd=1.14u as=43.2f ps=0.6u w=0.36u l=0.6u
X1145 VDD.t1454 a_14460_17272# a_14372_17316# VDD.t1453 pfet_05v0 ad=0.5368p pd=3.32u as=0.5368p ps=3.32u w=1.22u l=1u
X1146 a_21709_808# ana_vco_in.t0 VSS VSS nfet_05v0 ad=0.333p pd=2.57u as=93.59999f ps=0.88u w=0.36u l=0.6u
X1147 VDD.t1303 a_13228_8999# a_13140_9096# VDD.t1302 pfet_05v0 ad=0.5368p pd=3.32u as=0.5368p ps=3.32u w=1.22u l=1u
X1148 a_1916_14136# a_1828_14180# VSS VSS nfet_05v0 ad=0.3608p pd=2.52u as=0.3608p ps=2.52u w=0.82u l=1u
X1149 a_1916_11000# a_1828_11044# VSS VSS nfet_05v0 ad=0.3608p pd=2.52u as=0.3608p ps=2.52u w=0.82u l=1u
X1150 VDD.t1233 a_4604_12568# a_4516_12612# VDD.t1232 pfet_05v0 ad=0.5368p pd=3.32u as=0.5368p ps=3.32u w=1.22u l=1u
X1151 VDD.t1326 a_1020_16839# a_932_16936# VDD.t1107 pfet_05v0 ad=0.5368p pd=3.32u as=0.5368p ps=3.32u w=1.22u l=1u
X1152 a_15468_16839# a_15380_16936# VSS VSS nfet_05v0 ad=0.3608p pd=2.52u as=0.3608p ps=2.52u w=0.82u l=1u
X1153 VDD.t1816 a_6172_1159# a_6084_1256# VDD.t1815 pfet_05v0 ad=0.5368p pd=3.32u as=0.5368p ps=3.32u w=1.22u l=1u
X1154 VDD.t1140 a_17596_6296# a_17508_6340# VDD.t1139 pfet_05v0 ad=0.5368p pd=3.32u as=0.5368p ps=3.32u w=1.22u l=1u
X1155 VDD.t360 a_17596_3160# a_17508_3204# VDD.t359 pfet_05v0 ad=0.5368p pd=3.32u as=0.5368p ps=3.32u w=1.22u l=1u
X1156 VDD.t25 a_4940_5863# a_4852_5960# VDD.t24 pfet_05v0 ad=0.5368p pd=3.32u as=0.5368p ps=3.32u w=1.22u l=1u
X1157 VDD.t1820 a_4940_2727# a_4852_2824# VDD.t1819 pfet_05v0 ad=0.5368p pd=3.32u as=0.5368p ps=3.32u w=1.22u l=1u
X1158 a_17148_7864# a_17060_7908# VSS VSS nfet_05v0 ad=0.3608p pd=2.52u as=0.3608p ps=2.52u w=0.82u l=1u
X1159 a_18604_12135# a_18516_12232# VSS VSS nfet_05v0 ad=0.3608p pd=2.52u as=0.3608p ps=2.52u w=0.82u l=1u
X1160 a_17148_4728# a_17060_4772# VSS VSS nfet_05v0 ad=0.3608p pd=2.52u as=0.3608p ps=2.52u w=0.82u l=1u
X1161 VDD.t677 a_19276_18407# a_19188_18504# VDD.t676 pfet_05v0 ad=0.5368p pd=3.32u as=0.5368p ps=3.32u w=1.22u l=1u
X1162 VDD.t267 a_20732_7864# a_20644_7908# VDD.t266 pfet_05v0 ad=0.5368p pd=3.32u as=0.5368p ps=3.32u w=1.22u l=1u
X1163 a_14124_10567# a_14036_10664# VSS VSS nfet_05v0 ad=0.3608p pd=2.52u as=0.3608p ps=2.52u w=0.82u l=1u
X1164 VDD.t2030 a_19052_10567# a_18964_10664# VDD.t2029 pfet_05v0 ad=0.5368p pd=3.32u as=0.5368p ps=3.32u w=1.22u l=1u
X1165 VDD.t418 a_12668_14136# a_12580_14180# VDD.t417 pfet_05v0 ad=0.5368p pd=3.32u as=0.5368p ps=3.32u w=1.22u l=1u
X1166 VDD.t31 a_9420_4295# a_9332_4392# VDD.t30 pfet_05v0 ad=0.5368p pd=3.32u as=0.5368p ps=3.32u w=1.22u l=1u
X1167 ana_div_chain\[1\]_inv_notouch_.ZN wire18.I VSS VSS nfet_05v0 ad=0.3608p pd=2.52u as=0.3608p ps=2.52u w=0.82u l=0.6u
X1168 a_11264_13443# a_10971_13855# VDD.t930 VDD.t929 pfet_05v0 ad=0.352p pd=2.48u as=0.23p ps=1.54u w=0.8u l=0.5u
X1169 VDD.t616 a_16700_13703# a_16612_13800# VDD.t476 pfet_05v0 ad=0.5368p pd=3.32u as=0.5368p ps=3.32u w=1.22u l=1u
X1170 a_12108_9432# a_12020_9476# VSS VSS nfet_05v0 ad=0.3608p pd=2.52u as=0.3608p ps=2.52u w=0.82u l=1u
X1171 a_9308_14136# a_9220_14180# VSS VSS nfet_05v0 ad=0.3608p pd=2.52u as=0.3608p ps=2.52u w=0.82u l=1u
X1172 VDD.t87 a_7628_5863# a_7540_5960# VDD.t86 pfet_05v0 ad=0.5368p pd=3.32u as=0.5368p ps=3.32u w=1.22u l=1u
X1173 VDD.t71 a_7628_2727# a_7540_2824# VDD.t70 pfet_05v0 ad=0.5368p pd=3.32u as=0.5368p ps=3.32u w=1.22u l=1u
X1174 a_13788_1592# a_13700_1636# VSS VSS nfet_05v0 ad=0.3608p pd=2.52u as=0.3608p ps=2.52u w=0.82u l=1u
X1175 VDD.t428 a_5052_17272# a_4964_17316# VDD.t427 pfet_05v0 ad=0.5368p pd=3.32u as=0.5368p ps=3.32u w=1.22u l=1u
X1176 VDD.t1246 a_17148_7864# a_17060_7908# VDD.t1245 pfet_05v0 ad=0.5368p pd=3.32u as=0.5368p ps=3.32u w=1.22u l=1u
X1177 VDD.t241 a_14236_1159# a_14148_1256# VDD.t151 pfet_05v0 ad=0.5368p pd=3.32u as=0.5368p ps=3.32u w=1.22u l=1u
X1178 VDD.t592 a_11212_8999# a_11124_9096# VDD.t591 pfet_05v0 ad=0.5368p pd=3.32u as=0.5368p ps=3.32u w=1.22u l=1u
X1179 a_7628_13703# a_7540_13800# VSS VSS nfet_05v0 ad=0.3608p pd=2.52u as=0.3608p ps=2.52u w=0.82u l=1u
X1180 a_1020_12568# a_932_12612# VSS VSS nfet_05v0 ad=0.3608p pd=2.52u as=0.3608p ps=2.52u w=0.82u l=1u
X1181 a_1020_7431# a_932_7528# VSS VSS nfet_05v0 ad=0.3608p pd=2.52u as=0.3608p ps=2.52u w=0.82u l=1u
X1182 a_18940_7864# a_18852_7908# VSS VSS nfet_05v0 ad=0.3608p pd=2.52u as=0.3608p ps=2.52u w=0.82u l=1u
X1183 a_10652_9432# a_10564_9476# VSS VSS nfet_05v0 ad=0.3608p pd=2.52u as=0.3608p ps=2.52u w=0.82u l=1u
X1184 a_18940_4728# a_18852_4772# VSS VSS nfet_05v0 ad=0.3608p pd=2.52u as=0.3608p ps=2.52u w=0.82u l=1u
X1185 a_14572_8999# a_14484_9096# VSS VSS nfet_05v0 ad=0.3608p pd=2.52u as=0.3608p ps=2.52u w=0.82u l=1u
X1186 a_21516_16839# a_21428_16936# VSS VSS nfet_05v0 ad=0.3608p pd=2.52u as=0.3608p ps=2.52u w=0.82u l=1u
X1187 a_10652_6296# a_10564_6340# VSS VSS nfet_05v0 ad=0.3608p pd=2.52u as=0.3608p ps=2.52u w=0.82u l=1u
X1188 a_4940_10567# a_4852_10664# VSS VSS nfet_05v0 ad=0.3608p pd=2.52u as=0.3608p ps=2.52u w=0.82u l=1u
X1189 a_14572_5863# a_14484_5960# VSS VSS nfet_05v0 ad=0.3608p pd=2.52u as=0.3608p ps=2.52u w=0.82u l=1u
X1190 a_10316_16839# a_10228_16936# VSS VSS nfet_05v0 ad=0.3608p pd=2.52u as=0.3608p ps=2.52u w=0.82u l=1u
X1191 VDD.t860 a_15580_6296# a_15492_6340# VDD.t859 pfet_05v0 ad=0.5368p pd=3.32u as=0.5368p ps=3.32u w=1.22u l=1u
X1192 a_1916_10567# a_1828_10664# VSS VSS nfet_05v0 ad=0.3608p pd=2.52u as=0.3608p ps=2.52u w=0.82u l=1u
X1193 VDD.t852 a_15580_3160# a_15492_3204# VDD.t851 pfet_05v0 ad=0.5368p pd=3.32u as=0.5368p ps=3.32u w=1.22u l=1u
X1194 VDD.t1168 a_17708_8999# a_17620_9096# VDD.t1167 pfet_05v0 ad=0.5368p pd=3.32u as=0.5368p ps=3.32u w=1.22u l=1u
X1195 a_15132_7864# a_15044_7908# VSS VSS nfet_05v0 ad=0.3608p pd=2.52u as=0.3608p ps=2.52u w=0.82u l=1u
X1196 a_20755_808# a_21085_808# a_21205_852# VSS nfet_05v0 ad=0.3705p pd=2.77u as=43.8f ps=0.605u w=0.365u l=0.6u
X1197 VDD.t380 a_12780_4295# a_12692_4392# VDD.t379 pfet_05v0 ad=0.5368p pd=3.32u as=0.5368p ps=3.32u w=1.22u l=1u
X1198 a_15132_4728# a_15044_4772# VSS VSS nfet_05v0 ad=0.3608p pd=2.52u as=0.3608p ps=2.52u w=0.82u l=1u
X1199 VDD.t2007 a_2364_5863# a_2276_5960# VDD.t1205 pfet_05v0 ad=0.5368p pd=3.32u as=0.5368p ps=3.32u w=1.22u l=1u
X1200 VSS dac_div_chain\[3\]_inv_notouch_.I dac_div_chain\[3\]_inv_notouch_.ZN VSS nfet_05v0 ad=0.3608p pd=2.52u as=0.3608p ps=2.52u w=0.82u l=0.6u
X1201 wire20.I a_13272_13352# VSS VSS nfet_05v0 ad=0.2132p pd=1.34u as=0.3608p ps=2.52u w=0.82u l=0.6u
X1202 VDD.t484 a_2364_2727# a_2276_2824# VDD.t373 pfet_05v0 ad=0.5368p pd=3.32u as=0.5368p ps=3.32u w=1.22u l=1u
X1203 a_13900_9432# a_13812_9476# VSS VSS nfet_05v0 ad=0.3608p pd=2.52u as=0.3608p ps=2.52u w=0.82u l=1u
X1204 a_6396_1592# a_6308_1636# VSS VSS nfet_05v0 ad=0.3608p pd=2.52u as=0.3608p ps=2.52u w=0.82u l=1u
X1205 a_2812_17272# a_2724_17316# VSS VSS nfet_05v0 ad=0.3608p pd=2.52u as=0.3608p ps=2.52u w=0.82u l=1u
X1206 a_15916_2727# a_15828_2824# VSS VSS nfet_05v0 ad=0.3608p pd=2.52u as=0.3608p ps=2.52u w=0.82u l=1u
X1207 a_14572_10567# a_14484_10664# VSS VSS nfet_05v0 ad=0.3608p pd=2.52u as=0.3608p ps=2.52u w=0.82u l=1u
X1208 VDD.t1717 a_1020_15704# a_932_15748# VDD.t1716 pfet_05v0 ad=0.5368p pd=3.32u as=0.5368p ps=3.32u w=1.22u l=1u
X1209 VDD.t1765 a_5836_7431# a_5748_7528# VDD.t1764 pfet_05v0 ad=0.5368p pd=3.32u as=0.5368p ps=3.32u w=1.22u l=1u
X1210 a_3260_9432# a_3172_9476# VSS VSS nfet_05v0 ad=0.3608p pd=2.52u as=0.3608p ps=2.52u w=0.82u l=1u
X1211 a_19040_12683# a_18628_13096# VDD.t530 VDD.t529 pfet_05v0 ad=0.3806p pd=2.61u as=0.2249p ps=1.385u w=0.865u l=0.5u
X1212 VDD.t1794 a_18940_7864# a_18852_7908# VDD.t1793 pfet_05v0 ad=0.5368p pd=3.32u as=0.5368p ps=3.32u w=1.22u l=1u
X1213 a_7180_8999# a_7092_9096# VSS VSS nfet_05v0 ad=0.3608p pd=2.52u as=0.3608p ps=2.52u w=0.82u l=1u
X1214 a_3260_6296# a_3172_6340# VSS VSS nfet_05v0 ad=0.3608p pd=2.52u as=0.3608p ps=2.52u w=0.82u l=1u
X1215 a_12192_13053# dac_div_chain\[1\]_dff_notouch_.CLK VSS VSS nfet_05v0 ad=0.1782p pd=1.69u as=0.1053p ps=0.925u w=0.405u l=0.6u
X1216 a_7180_5863# a_7092_5960# VSS VSS nfet_05v0 ad=0.3608p pd=2.52u as=0.3608p ps=2.52u w=0.82u l=1u
X1217 VDD.t262 a_15468_4295# a_15380_4392# VDD.t261 pfet_05v0 ad=0.5368p pd=3.32u as=0.5368p ps=3.32u w=1.22u l=1u
X1218 a_12108_2727# a_12020_2824# VSS VSS nfet_05v0 ad=0.3608p pd=2.52u as=0.3608p ps=2.52u w=0.82u l=1u
X1219 a_8188_17272# a_8100_17316# VSS VSS nfet_05v0 ad=0.3608p pd=2.52u as=0.3608p ps=2.52u w=0.82u l=1u
X1220 a_9756_9432# a_9668_9476# VSS VSS nfet_05v0 ad=0.3608p pd=2.52u as=0.3608p ps=2.52u w=0.82u l=1u
X1221 a_9756_14136# a_9668_14180# VSS VSS nfet_05v0 ad=0.3608p pd=2.52u as=0.3608p ps=2.52u w=0.82u l=1u
X1222 a_9756_6296# a_9668_6340# VSS VSS nfet_05v0 ad=0.3608p pd=2.52u as=0.3608p ps=2.52u w=0.82u l=1u
X1223 VDD.t2100 a_15132_7864# a_15044_7908# VDD.t2099 pfet_05v0 ad=0.5368p pd=3.32u as=0.5368p ps=3.32u w=1.22u l=1u
X1224 a_1916_1159# a_1828_1256# VSS VSS nfet_05v0 ad=0.3608p pd=2.52u as=0.3608p ps=2.52u w=0.82u l=1u
X1225 VDD.t835 a_21180_9432# a_21092_9476# VDD.t834 pfet_05v0 ad=0.5368p pd=3.32u as=0.5368p ps=3.32u w=1.22u l=1u
X1226 VDD.t1465 a_16700_12568# a_16612_12612# VDD.t1464 pfet_05v0 ad=0.5368p pd=3.32u as=0.5368p ps=3.32u w=1.22u l=1u
X1227 a_8524_2727# a_8436_2824# VSS VSS nfet_05v0 ad=0.3608p pd=2.52u as=0.3608p ps=2.52u w=0.82u l=1u
X1228 VDD.t1560 a_4604_9432# a_4516_9476# VDD.t1559 pfet_05v0 ad=0.5368p pd=3.32u as=0.5368p ps=3.32u w=1.22u l=1u
X1229 a_21964_16839# a_21876_16936# VSS VSS nfet_05v0 ad=0.3608p pd=2.52u as=0.3608p ps=2.52u w=0.82u l=1u
X1230 a_10764_16839# a_10676_16936# VSS VSS nfet_05v0 ad=0.3608p pd=2.52u as=0.3608p ps=2.52u w=0.82u l=1u
X1231 a_19388_14136# a_19300_14180# VSS VSS nfet_05v0 ad=0.3608p pd=2.52u as=0.3608p ps=2.52u w=0.82u l=1u
X1232 VDD.t109 a_8076_4295# a_7988_4392# VDD.t108 pfet_05v0 ad=0.5368p pd=3.32u as=0.5368p ps=3.32u w=1.22u l=1u
X1233 a_21516_8999# a_21428_9096# VSS VSS nfet_05v0 ad=0.3608p pd=2.52u as=0.3608p ps=2.52u w=0.82u l=1u
X1234 a_19388_11000# a_19300_11044# VSS VSS nfet_05v0 ad=0.3608p pd=2.52u as=0.3608p ps=2.52u w=0.82u l=1u
X1235 VDD.t1001 a_19948_12135# a_19860_12232# VDD.t1000 pfet_05v0 ad=0.5368p pd=3.32u as=0.5368p ps=3.32u w=1.22u l=1u
X1236 a_13160_15865# a_11312_15819# a_12875_15865# VDD.t1050 pfet_05v0 ad=50.4f pd=0.64u as=0.1665p ps=1.285u w=0.36u l=0.5u
X1237 a_21516_5863# a_21428_5960# VSS VSS nfet_05v0 ad=0.3608p pd=2.52u as=0.3608p ps=2.52u w=0.82u l=1u
X1238 a_8732_11919# dac_div_chain\[2\]_dff_notouch_.D a_8608_12287# VDD.t1271 pfet_05v0 ad=0.1872p pd=1.4u as=54f ps=0.66u w=0.36u l=0.5u
X1239 a_8524_16839# a_8436_16936# VSS VSS nfet_05v0 ad=0.3608p pd=2.52u as=0.3608p ps=2.52u w=0.82u l=1u
X1240 a_20620_10567# a_20532_10664# VSS VSS nfet_05v0 ad=0.3608p pd=2.52u as=0.3608p ps=2.52u w=0.82u l=1u
X1241 VDD.t594 dac_div_chain\[4\]_dff_notouch_.CLK a_10900_16232# VDD.t593 pfet_05v0 ad=0.2249p pd=1.385u as=0.3806p ps=2.61u w=0.865u l=0.5u
X1242 a_15692_13487# dac_div_chain\[0\]_inv_notouch_.ZN a_14768_13443# VSS nfet_05v0 ad=43.2f pd=0.6u as=0.207p ps=1.51u w=0.36u l=0.6u
X1243 wire12.I a_10032_11875# VSS VSS nfet_05v0 ad=0.2132p pd=1.34u as=0.3608p ps=2.52u w=0.82u l=0.6u
X1244 VDD.t1301 a_13676_8999# a_13588_9096# VDD.t1300 pfet_05v0 ad=0.5368p pd=3.32u as=0.5368p ps=3.32u w=1.22u l=1u
X1245 a_10316_7431# a_10228_7528# VSS VSS nfet_05v0 ad=0.3608p pd=2.52u as=0.3608p ps=2.52u w=0.82u l=1u
X1246 a_19276_15271# a_19188_15368# VSS VSS nfet_05v0 ad=0.3608p pd=2.52u as=0.3608p ps=2.52u w=0.82u l=1u
X1247 a_14320_13443# input2.Z VDD.t1578 VDD.t1577 pfet_05v0 ad=0.3806p pd=2.61u as=0.2249p ps=1.385u w=0.865u l=0.5u
X1248 a_1468_15704# a_1380_15748# VSS VSS nfet_05v0 ad=0.3608p pd=2.52u as=0.3608p ps=2.52u w=0.82u l=1u
X1249 a_3260_2727# a_3172_2824# VSS VSS nfet_05v0 ad=0.3608p pd=2.52u as=0.3608p ps=2.52u w=0.82u l=1u
X1250 VSS a_8963_18100# a_8963_18100# VSS nfet_05v0 ad=0.3608p pd=2.52u as=0.3608p ps=2.52u w=0.82u l=0.6u
X1251 VDD.t169 a_2364_4728# a_2276_4772# VDD.t104 pfet_05v0 ad=0.5368p pd=3.32u as=0.5368p ps=3.32u w=1.22u l=1u
X1252 a_7740_9432# a_7652_9476# VSS VSS nfet_05v0 ad=0.3608p pd=2.52u as=0.3608p ps=2.52u w=0.82u l=1u
X1253 a_4604_14136# a_4516_14180# VSS VSS nfet_05v0 ad=0.3608p pd=2.52u as=0.3608p ps=2.52u w=0.82u l=1u
X1254 VDD.t256 a_2364_1592# a_2276_1636# VDD.t255 pfet_05v0 ad=0.5368p pd=3.32u as=0.5368p ps=3.32u w=1.22u l=1u
X1255 a_13340_1159# a_13252_1256# VSS VSS nfet_05v0 ad=0.3608p pd=2.52u as=0.3608p ps=2.52u w=0.82u l=1u
X1256 a_5724_1159# a_5636_1256# VSS VSS nfet_05v0 ad=0.3608p pd=2.52u as=0.3608p ps=2.52u w=0.82u l=1u
X1257 a_7740_6296# a_7652_6340# VSS VSS nfet_05v0 ad=0.3608p pd=2.52u as=0.3608p ps=2.52u w=0.82u l=1u
X1258 a_4604_11000# a_4516_11044# VSS VSS nfet_05v0 ad=0.3608p pd=2.52u as=0.3608p ps=2.52u w=0.82u l=1u
X1259 a_17596_7864# a_17508_7908# VSS VSS nfet_05v0 ad=0.3608p pd=2.52u as=0.3608p ps=2.52u w=0.82u l=1u
X1260 VDD.t507 a_19948_4295# a_19860_4392# VDD.t506 pfet_05v0 ad=0.5368p pd=3.32u as=0.5368p ps=3.32u w=1.22u l=1u
X1261 a_17596_4728# a_17508_4772# VSS VSS nfet_05v0 ad=0.3608p pd=2.52u as=0.3608p ps=2.52u w=0.82u l=1u
X1262 VSS a_11264_13443# a_11216_13487# VSS nfet_05v0 ad=0.142p pd=1.14u as=43.2f ps=0.6u w=0.36u l=0.6u
X1263 a_6732_7431# a_6644_7528# VSS VSS nfet_05v0 ad=0.3608p pd=2.52u as=0.3608p ps=2.52u w=0.82u l=1u
X1264 VDD.t1308 a_15916_10567# a_15828_10664# VDD.t1287 pfet_05v0 ad=0.5368p pd=3.32u as=0.5368p ps=3.32u w=1.22u l=1u
X1265 a_13272_11161# a_11424_11115# a_12987_11161# VDD.t809 pfet_05v0 ad=50.4f pd=0.64u as=0.1665p ps=1.285u w=0.36u l=0.5u
X1266 VDD.t554 a_6284_16839# a_6196_16936# VDD.t553 pfet_05v0 ad=0.5368p pd=3.32u as=0.5368p ps=3.32u w=1.22u l=1u
X1267 a_12444_1592# a_12356_1636# VSS VSS nfet_05v0 ad=0.3608p pd=2.52u as=0.3608p ps=2.52u w=0.82u l=1u
X1268 VDD.t899 a_6284_8999# a_6196_9096# VDD.t898 pfet_05v0 ad=0.5368p pd=3.32u as=0.5368p ps=3.32u w=1.22u l=1u
X1269 a_12556_9432# a_12468_9476# VSS VSS nfet_05v0 ad=0.3608p pd=2.52u as=0.3608p ps=2.52u w=0.82u l=1u
X1270 a_9408_13800# a_8996_13479# VSS VSS nfet_05v0 ad=0.1782p pd=1.69u as=0.1053p ps=0.925u w=0.405u l=0.6u
X1271 ana_div_chain\[3\]_inv_notouch_.ZN ana_div_chain\[3\]_inv_notouch_.I VSS VSS nfet_05v0 ad=0.3608p pd=2.52u as=0.3608p ps=2.52u w=0.82u l=0.6u
X1272 VSS avo[3].t7 a_10340_11575# VSS nfet_05v0 ad=0.153p pd=1.195u as=0.1584p ps=1.6u w=0.36u l=0.6u
X1273 VDD.t1118 a_6732_15271# a_6644_15368# VDD.t1117 pfet_05v0 ad=0.5368p pd=3.32u as=0.5368p ps=3.32u w=1.22u l=1u
X1274 VDD.t1344 a_21180_17272# a_21092_17316# VDD.t1343 pfet_05v0 ad=0.5368p pd=3.32u as=0.5368p ps=3.32u w=1.22u l=1u
X1275 VDD.t1029 a_3708_15271# a_3620_15368# VDD.t682 pfet_05v0 ad=0.5368p pd=3.32u as=0.5368p ps=3.32u w=1.22u l=1u
X1276 a_8860_1592# a_8772_1636# VSS VSS nfet_05v0 ad=0.3608p pd=2.52u as=0.3608p ps=2.52u w=0.82u l=1u
X1277 VDD.t99 a_17596_7864# a_17508_7908# VDD.t98 pfet_05v0 ad=0.5368p pd=3.32u as=0.5368p ps=3.32u w=1.22u l=1u
X1278 VDD.t456 a_16192_15011# a_16184_15423# VDD.t455 pfet_05v0 ad=0.23p pd=1.54u as=50.4f ps=0.64u w=0.36u l=0.5u
X1279 VDD.t590 a_11660_8999# a_11572_9096# VDD.t589 pfet_05v0 ad=0.5368p pd=3.32u as=0.5368p ps=3.32u w=1.22u l=1u
X1280 VDD.t1385 a_1916_17272# a_1828_17316# VDD.t1215 pfet_05v0 ad=0.5368p pd=3.32u as=0.5368p ps=3.32u w=1.22u l=1u
X1281 a_13876_13639# a_14320_13443# a_14272_13487# VSS nfet_05v0 ad=93.59999f pd=0.88u as=43.2f ps=0.6u w=0.36u l=0.6u
X1282 VDD.t388 a_14684_1159# a_14596_1256# VDD.t387 pfet_05v0 ad=0.5368p pd=3.32u as=0.5368p ps=3.32u w=1.22u l=1u
X1283 VSS a_12352_11485# a_12304_11529# VSS nfet_05v0 ad=0.2637p pd=1.825u as=43.2f ps=0.6u w=0.36u l=0.6u
X1284 a_8972_16839# a_8884_16936# VSS VSS nfet_05v0 ad=0.3608p pd=2.52u as=0.3608p ps=2.52u w=0.82u l=1u
X1285 a_9532_1159# a_9444_1256# VSS VSS nfet_05v0 ad=0.3608p pd=2.52u as=0.3608p ps=2.52u w=0.82u l=1u
X1286 VDD.t1787 a_1020_5863# a_932_5960# VDD.t1786 pfet_05v0 ad=0.5368p pd=3.32u as=0.5368p ps=3.32u w=1.22u l=1u
X1287 VDD.t486 a_1020_2727# a_932_2824# VDD.t485 pfet_05v0 ad=0.5368p pd=3.32u as=0.5368p ps=3.32u w=1.22u l=1u
X1288 a_5052_1592# a_4964_1636# VSS VSS nfet_05v0 ad=0.3608p pd=2.52u as=0.3608p ps=2.52u w=0.82u l=1u
X1289 a_15580_7864# a_15492_7908# VSS VSS nfet_05v0 ad=0.3608p pd=2.52u as=0.3608p ps=2.52u w=0.82u l=1u
X1290 a_15580_4728# a_15492_4772# VSS VSS nfet_05v0 ad=0.3608p pd=2.52u as=0.3608p ps=2.52u w=0.82u l=1u
X1291 a_5836_4295# a_5748_4392# VSS VSS nfet_05v0 ad=0.3608p pd=2.52u as=0.3608p ps=2.52u w=0.82u l=1u
X1292 VDD.t1749 a_6844_4728# a_6756_4772# VDD.t1748 pfet_05v0 ad=0.5368p pd=3.32u as=0.5368p ps=3.32u w=1.22u l=1u
X1293 VDD.t232 a_6844_1592# a_6756_1636# VDD.t231 pfet_05v0 ad=0.5368p pd=3.32u as=0.5368p ps=3.32u w=1.22u l=1u
X1294 VDD.t1273 a_7740_12568# a_7652_12612# VDD.t1272 pfet_05v0 ad=0.5368p pd=3.32u as=0.5368p ps=3.32u w=1.22u l=1u
X1295 a_17708_15704# a_17620_15748# VSS VSS nfet_05v0 ad=0.3608p pd=2.52u as=0.3608p ps=2.52u w=0.82u l=1u
X1296 VDD.t1912 a_1916_6296# a_1828_6340# VDD.t102 pfet_05v0 ad=0.5368p pd=3.32u as=0.5368p ps=3.32u w=1.22u l=1u
X1297 a_4156_7431# a_4068_7528# VSS VSS nfet_05v0 ad=0.3608p pd=2.52u as=0.3608p ps=2.52u w=0.82u l=1u
X1298 a_13788_6296# a_13700_6340# VSS VSS nfet_05v0 ad=0.3608p pd=2.52u as=0.3608p ps=2.52u w=0.82u l=1u
X1299 VDD.t2022 a_1916_3160# a_1828_3204# VDD.t423 pfet_05v0 ad=0.5368p pd=3.32u as=0.5368p ps=3.32u w=1.22u l=1u
X1300 VDD.t2067 a_14124_4295# a_14036_4392# VDD.t2066 pfet_05v0 ad=0.5368p pd=3.32u as=0.5368p ps=3.32u w=1.22u l=1u
X1301 VDD.t620 a_21404_14136# a_21316_14180# VDD.t619 pfet_05v0 ad=0.5368p pd=3.32u as=0.5368p ps=3.32u w=1.22u l=1u
X1302 VDD.t1334 a_9308_17272# a_9220_17316# VDD.t1333 pfet_05v0 ad=0.5368p pd=3.32u as=0.5368p ps=3.32u w=1.22u l=1u
X1303 VDD.t696 a_10204_14136# a_10116_14180# VDD.t695 pfet_05v0 ad=0.5368p pd=3.32u as=0.5368p ps=3.32u w=1.22u l=1u
X1304 a_5500_17272# a_5412_17316# VSS VSS nfet_05v0 ad=0.3608p pd=2.52u as=0.3608p ps=2.52u w=0.82u l=1u
X1305 a_20060_1159# a_19972_1256# VSS VSS nfet_05v0 ad=0.3608p pd=2.52u as=0.3608p ps=2.52u w=0.82u l=1u
X1306 a_16184_15423# a_14336_15368# a_15899_15423# VDD.t614 pfet_05v0 ad=50.4f pd=0.64u as=0.1665p ps=1.285u w=0.36u l=0.5u
X1307 a_17260_10567# a_17172_10664# VSS VSS nfet_05v0 ad=0.3608p pd=2.52u as=0.3608p ps=2.52u w=0.82u l=1u
X1308 a_4940_15271# a_4852_15368# VSS VSS nfet_05v0 ad=0.3608p pd=2.52u as=0.3608p ps=2.52u w=0.82u l=1u
X1309 a_1916_15271# a_1828_15368# VSS VSS nfet_05v0 ad=0.3608p pd=2.52u as=0.3608p ps=2.52u w=0.82u l=1u
X1310 a_4940_12135# a_4852_12232# VSS VSS nfet_05v0 ad=0.3608p pd=2.52u as=0.3608p ps=2.52u w=0.82u l=1u
X1311 VDD.t869 a_15580_7864# a_15492_7908# VDD.t868 pfet_05v0 ad=0.5368p pd=3.32u as=0.5368p ps=3.32u w=1.22u l=1u
X1312 a_1916_12135# a_1828_12232# VSS VSS nfet_05v0 ad=0.3608p pd=2.52u as=0.3608p ps=2.52u w=0.82u l=1u
X1313 VDD.t1719 avo[2].t6 a_10340_13143# VDD.t1718 pfet_05v0 ad=0.4015p pd=1.92u as=0.462p ps=2.98u w=1.05u l=0.5u
X1314 VDD.t558 a_2364_10567# a_2276_10664# VDD.t557 pfet_05v0 ad=0.5368p pd=3.32u as=0.5368p ps=3.32u w=1.22u l=1u
X1315 VDD.t1521 a_2588_18407# a_2500_18504# VDD.t1520 pfet_05v0 ad=0.5368p pd=3.32u as=0.5368p ps=3.32u w=1.22u l=1u
X1316 a_6396_9432# a_6308_9476# VSS VSS nfet_05v0 ad=0.3608p pd=2.52u as=0.3608p ps=2.52u w=0.82u l=1u
X1317 VDD.t398 a_21740_15704# a_21652_15748# VDD.t397 pfet_05v0 ad=0.5368p pd=3.32u as=0.5368p ps=3.32u w=1.22u l=1u
X1318 dac_div_chain\[2\]_dff_notouch_.D dac_div_chain\[2\]_load_slew11.Z VDD.t1554 VDD.t1553 pfet_05v0 ad=0.5368p pd=3.32u as=0.5368p ps=3.32u w=1.22u l=0.5u
X1319 a_6396_6296# a_6308_6340# VSS VSS nfet_05v0 ad=0.3608p pd=2.52u as=0.3608p ps=2.52u w=0.82u l=1u
X1320 a_16700_14136# a_16612_14180# VSS VSS nfet_05v0 ad=0.3608p pd=2.52u as=0.3608p ps=2.52u w=0.82u l=1u
X1321 a_8972_2727# a_8884_2824# VSS VSS nfet_05v0 ad=0.3608p pd=2.52u as=0.3608p ps=2.52u w=0.82u l=1u
X1322 a_14224_13855# a_13272_13352# VDD.t2040 VDD.t2039 pfet_05v0 ad=50.4f pd=0.64u as=0.23p ps=1.54u w=0.36u l=0.5u
X1323 a_16700_11000# a_16612_11044# VSS VSS nfet_05v0 ad=0.3608p pd=2.52u as=0.3608p ps=2.52u w=0.82u l=1u
X1324 VDD.t1194 a_11212_15271# a_11124_15368# VDD.t1193 pfet_05v0 ad=0.5368p pd=3.32u as=0.5368p ps=3.32u w=1.22u l=1u
X1325 a_12987_11161# a_11424_11115# a_12352_11485# VSS nfet_05v0 ad=93.59999f pd=0.88u as=93.59999f ps=0.88u w=0.36u l=0.6u
X1326 a_5388_7431# a_5300_7528# VSS VSS nfet_05v0 ad=0.3608p pd=2.52u as=0.3608p ps=2.52u w=0.82u l=1u
X1327 a_21964_8999# a_21876_9096# VSS VSS nfet_05v0 ad=0.3608p pd=2.52u as=0.3608p ps=2.52u w=0.82u l=1u
X1328 a_21964_5863# a_21876_5960# VSS VSS nfet_05v0 ad=0.3608p pd=2.52u as=0.3608p ps=2.52u w=0.82u l=1u
X1329 dvo[1].t3 a_14708_12612# VDD.t1642 VDD.t1641 pfet_05v0 ad=0.3782p pd=1.84u as=0.4941p ps=2.03u w=1.22u l=0.5u
X1330 VDD.t1442 a_5388_13703# a_5300_13800# VDD.t1441 pfet_05v0 ad=0.5368p pd=3.32u as=0.5368p ps=3.32u w=1.22u l=1u
X1331 VDD.t203 a_1020_4728# a_932_4772# VDD.t202 pfet_05v0 ad=0.5368p pd=3.32u as=0.5368p ps=3.32u w=1.22u l=1u
X1332 VDD.t489 a_1020_1592# a_932_1636# VDD.t284 pfet_05v0 ad=0.5368p pd=3.32u as=0.5368p ps=3.32u w=1.22u l=1u
X1333 a_10764_7431# a_10676_7528# VSS VSS nfet_05v0 ad=0.3608p pd=2.52u as=0.3608p ps=2.52u w=0.82u l=1u
X1334 VDD.t1340 a_6396_14136# a_6308_14180# VDD.t1339 pfet_05v0 ad=0.5368p pd=3.32u as=0.5368p ps=3.32u w=1.22u l=1u
X1335 VDD.t781 a_18604_4295# a_18516_4392# VDD.t780 pfet_05v0 ad=0.5368p pd=3.32u as=0.5368p ps=3.32u w=1.22u l=1u
X1336 a_20508_18407# a_20420_18504# VSS VSS nfet_05v0 ad=0.3608p pd=2.52u as=0.3608p ps=2.52u w=0.82u l=1u
X1337 VDD.t83 a_10316_5863# a_10228_5960# VDD.t82 pfet_05v0 ad=0.5368p pd=3.32u as=0.5368p ps=3.32u w=1.22u l=1u
X1338 VDD.t392 a_6396_11000# a_6308_11044# VDD.t391 pfet_05v0 ad=0.5368p pd=3.32u as=0.5368p ps=3.32u w=1.22u l=1u
X1339 VDD.t1463 a_21852_14136# a_21764_14180# VDD.t1462 pfet_05v0 ad=0.5368p pd=3.32u as=0.5368p ps=3.32u w=1.22u l=1u
X1340 a_11264_13443# a_10971_13855# VSS VSS nfet_05v0 ad=0.176p pd=1.68u as=0.142p ps=1.14u w=0.4u l=0.6u
X1341 VDD.t1252 a_10316_2727# a_10228_2824# VDD.t1251 pfet_05v0 ad=0.5368p pd=3.32u as=0.5368p ps=3.32u w=1.22u l=1u
X1342 VDD.t1836 a_5836_12135# a_5748_12232# VDD.t1835 pfet_05v0 ad=0.5368p pd=3.32u as=0.5368p ps=3.32u w=1.22u l=1u
X1343 VDD.t406 a_14236_18407# a_14148_18504# VDD.t405 pfet_05v0 ad=0.5368p pd=3.32u as=0.5368p ps=3.32u w=1.22u l=1u
X1344 VDD.t1332 a_9756_17272# a_9668_17316# VDD.t1331 pfet_05v0 ad=0.5368p pd=3.32u as=0.5368p ps=3.32u w=1.22u l=1u
X1345 a_1020_13703# a_932_13800# VSS VSS nfet_05v0 ad=0.3608p pd=2.52u as=0.3608p ps=2.52u w=0.82u l=1u
X1346 a_20732_11000# a_20644_11044# VSS VSS nfet_05v0 ad=0.3608p pd=2.52u as=0.3608p ps=2.52u w=0.82u l=1u
X1347 a_4156_15704# a_4068_15748# VSS VSS nfet_05v0 ad=0.3608p pd=2.52u as=0.3608p ps=2.52u w=0.82u l=1u
X1348 a_2364_3160# a_2276_3204# VSS VSS nfet_05v0 ad=0.3608p pd=2.52u as=0.3608p ps=2.52u w=0.82u l=1u
X1349 a_11100_1592# a_11012_1636# VSS VSS nfet_05v0 ad=0.3608p pd=2.52u as=0.3608p ps=2.52u w=0.82u l=1u
X1350 VDD.t384 a_19388_6296# a_19300_6340# VDD.t383 pfet_05v0 ad=0.5368p pd=3.32u as=0.5368p ps=3.32u w=1.22u l=1u
X1351 VDD.t885 a_19388_3160# a_19300_3204# VDD.t884 pfet_05v0 ad=0.5368p pd=3.32u as=0.5368p ps=3.32u w=1.22u l=1u
X1352 VDD.t1598 a_19948_16839# a_19860_16936# VDD.t1597 pfet_05v0 ad=0.5368p pd=3.32u as=0.5368p ps=3.32u w=1.22u l=1u
X1353 VDD.t1763 a_6732_5863# a_6644_5960# VDD.t1762 pfet_05v0 ad=0.5368p pd=3.32u as=0.5368p ps=3.32u w=1.22u l=1u
X1354 VDD.t883 a_6732_2727# a_6644_2824# VDD.t882 pfet_05v0 ad=0.5368p pd=3.32u as=0.5368p ps=3.32u w=1.22u l=1u
X1355 VDD.t436 wire20.I a_14708_12612# VDD.t435 pfet_05v0 ad=0.4941p pd=2.03u as=0.5368p ps=3.32u w=1.22u l=0.5u
X1356 a_12892_1592# a_12804_1636# VSS VSS nfet_05v0 ad=0.3608p pd=2.52u as=0.3608p ps=2.52u w=0.82u l=1u
X1357 a_20620_15271# a_20532_15368# VSS VSS nfet_05v0 ad=0.3608p pd=2.52u as=0.3608p ps=2.52u w=0.82u l=1u
X1358 a_13228_2727# a_13140_2824# VSS VSS nfet_05v0 ad=0.3608p pd=2.52u as=0.3608p ps=2.52u w=0.82u l=1u
X1359 a_20620_12135# a_20532_12232# VSS VSS nfet_05v0 ad=0.3608p pd=2.52u as=0.3608p ps=2.52u w=0.82u l=1u
X1360 VDD.t1375 a_19388_17272# a_19300_17316# VDD.t1374 pfet_05v0 ad=0.5368p pd=3.32u as=0.5368p ps=3.32u w=1.22u l=1u
X1361 VDD.t1537 a_18828_18407# a_18740_18504# VDD.t1536 pfet_05v0 ad=0.5368p pd=3.32u as=0.5368p ps=3.32u w=1.22u l=1u
X1362 VSS dac_div_chain\[4\]_inv_notouch_.I dac_div_chain\[4\]_dff_notouch_.D VSS nfet_05v0 ad=0.3608p pd=2.52u as=0.3608p ps=2.52u w=0.82u l=0.6u
X1363 VSS dac_div_chain\[4\]_dff_notouch_.CLK a_10900_16232# VSS nfet_05v0 ad=0.1053p pd=0.925u as=0.1782p ps=1.69u w=0.405u l=0.6u
X1364 VDD.t2032 a_18604_10567# a_18516_10664# VDD.t2031 pfet_05v0 ad=0.5368p pd=3.32u as=0.5368p ps=3.32u w=1.22u l=1u
X1365 VDD.t713 a_13340_1159# a_13252_1256# VDD.t712 pfet_05v0 ad=0.5368p pd=3.32u as=0.5368p ps=3.32u w=1.22u l=1u
X1366 VDD.t471 a_11660_15271# a_11572_15368# VDD.t470 pfet_05v0 ad=0.5368p pd=3.32u as=0.5368p ps=3.32u w=1.22u l=1u
X1367 VDD.t600 a_3260_13703# a_3172_13800# VDD.t599 pfet_05v0 ad=0.5368p pd=3.32u as=0.5368p ps=3.32u w=1.22u l=1u
X1368 VDD.t1414 a_18044_14136# a_17956_14180# VDD.t1413 pfet_05v0 ad=0.5368p pd=3.32u as=0.5368p ps=3.32u w=1.22u l=1u
X1369 a_9868_7431# a_9780_7528# VSS VSS nfet_05v0 ad=0.3608p pd=2.52u as=0.3608p ps=2.52u w=0.82u l=1u
X1370 VDD.t1313 a_18044_11000# a_17956_11044# VDD.t1312 pfet_05v0 ad=0.5368p pd=3.32u as=0.5368p ps=3.32u w=1.22u l=1u
X1371 VSS a_1683_18100# a_1683_18100# VSS nfet_05v0 ad=0.3608p pd=2.52u as=0.3608p ps=2.52u w=0.82u l=0.6u
X1372 VDD.t1172 a_16812_8999# a_16724_9096# VDD.t1171 pfet_05v0 ad=0.5368p pd=3.32u as=0.5368p ps=3.32u w=1.22u l=1u
X1373 VDD.t1381 a_9420_15271# a_9332_15368# VDD.t1380 pfet_05v0 ad=0.5368p pd=3.32u as=0.5368p ps=3.32u w=1.22u l=1u
X1374 VDD.t608 ana_div_chain\[4\]_inv_notouch_.I ana_div_chain\[4\]_inv_notouch_.ZN VDD.t607 pfet_05v0 ad=0.5368p pd=3.32u as=0.5368p ps=3.32u w=1.22u l=0.5u
X1375 VDD.t1727 a_5500_4728# a_5412_4772# VDD.t1726 pfet_05v0 ad=0.5368p pd=3.32u as=0.5368p ps=3.32u w=1.22u l=1u
X1376 VDD.t430 a_4604_17272# a_4516_17316# VDD.t429 pfet_05v0 ad=0.5368p pd=3.32u as=0.5368p ps=3.32u w=1.22u l=1u
X1377 VDD.t283 a_5500_1592# a_5412_1636# VDD.t282 pfet_05v0 ad=0.5368p pd=3.32u as=0.5368p ps=3.32u w=1.22u l=1u
X1378 a_12144_13097# a_11144_12971# VSS VSS nfet_05v0 ad=43.2f pd=0.6u as=0.142p ps=1.14u w=0.36u l=0.6u
X1379 a_20956_18407# a_20868_18504# VSS VSS nfet_05v0 ad=0.3608p pd=2.52u as=0.3608p ps=2.52u w=0.82u l=1u
X1380 VSS a_15398_14516# dvo[0].t1 VSS nfet_05v0 ad=0.2911p pd=1.53u as=0.2132p ps=1.34u w=0.82u l=0.6u
X1381 a_12444_6296# a_12356_6340# VSS VSS nfet_05v0 ad=0.3608p pd=2.52u as=0.3608p ps=2.52u w=0.82u l=1u
X1382 a_16364_8999# a_16276_9096# VSS VSS nfet_05v0 ad=0.3608p pd=2.52u as=0.3608p ps=2.52u w=0.82u l=1u
X1383 VDD.t652 a_14684_18407# a_14596_18504# VDD.t651 pfet_05v0 ad=0.5368p pd=3.32u as=0.5368p ps=3.32u w=1.22u l=1u
X1384 a_16364_5863# a_16276_5960# VSS VSS nfet_05v0 ad=0.3608p pd=2.52u as=0.3608p ps=2.52u w=0.82u l=1u
X1385 VDD.t983 a_4940_7431# a_4852_7528# VDD.t982 pfet_05v0 ad=0.5368p pd=3.32u as=0.5368p ps=3.32u w=1.22u l=1u
X1386 VDD.t1638 a_15356_15704# a_15268_15748# VDD.t1637 pfet_05v0 ad=0.5368p pd=3.32u as=0.5368p ps=3.32u w=1.22u l=1u
X1387 VSS a_10336_13443# a_10288_13487# VSS nfet_05v0 ad=0.2637p pd=1.825u as=43.2f ps=0.6u w=0.36u l=0.6u
X1388 a_18208_16579# a_17915_16991# VDD.t1068 VDD.t1067 pfet_05v0 ad=0.352p pd=2.48u as=0.23p ps=1.54u w=0.8u l=0.5u
X1389 VDD.t483 a_8860_14136# a_8772_14180# VDD.t482 pfet_05v0 ad=0.5368p pd=3.32u as=0.5368p ps=3.32u w=1.22u l=1u
X1390 a_6844_3160# a_6756_3204# VSS VSS nfet_05v0 ad=0.3608p pd=2.52u as=0.3608p ps=2.52u w=0.82u l=1u
X1391 VDD.t23 a_14572_4295# a_14484_4392# VDD.t22 pfet_05v0 ad=0.5368p pd=3.32u as=0.5368p ps=3.32u w=1.22u l=1u
X1392 a_8792_10261# dvo[3].t6 VSS VSS nfet_05v0 ad=0.1584p pd=1.6u as=0.153p ps=1.195u w=0.36u l=0.6u
X1393 VDD.t1620 a_22076_11000# a_21988_11044# VDD.t1619 pfet_05v0 ad=0.5368p pd=3.32u as=0.5368p ps=3.32u w=1.22u l=1u
X1394 VDD.t1780 a_4156_5863# a_4068_5960# VDD.t1089 pfet_05v0 ad=0.5368p pd=3.32u as=0.5368p ps=3.32u w=1.22u l=1u
X1395 VDD.t1350 a_9420_8999# a_9332_9096# VDD.t1349 pfet_05v0 ad=0.5368p pd=3.32u as=0.5368p ps=3.32u w=1.22u l=1u
X1396 a_7740_14136# a_7652_14180# VSS VSS nfet_05v0 ad=0.3608p pd=2.52u as=0.3608p ps=2.52u w=0.82u l=1u
X1397 VDD.t1257 a_4156_2727# a_4068_2824# VDD.t504 pfet_05v0 ad=0.5368p pd=3.32u as=0.5368p ps=3.32u w=1.22u l=1u
X1398 a_11212_2727# a_11124_2824# VSS VSS nfet_05v0 ad=0.3608p pd=2.52u as=0.3608p ps=2.52u w=0.82u l=1u
X1399 VDD.t850 a_21516_12135# a_21428_12232# VDD.t849 pfet_05v0 ad=0.5368p pd=3.32u as=0.5368p ps=3.32u w=1.22u l=1u
X1400 a_1916_7864# a_1828_7908# VSS VSS nfet_05v0 ad=0.3608p pd=2.52u as=0.3608p ps=2.52u w=0.82u l=1u
X1401 a_8860_9432# a_8772_9476# VSS VSS nfet_05v0 ad=0.3608p pd=2.52u as=0.3608p ps=2.52u w=0.82u l=1u
X1402 a_8008_11504# dvo[2].t7 VSS VSS nfet_05v0 ad=0.1584p pd=1.6u as=0.153p ps=1.195u w=0.36u l=0.6u
X1403 VDD.t2052 a_16700_18407# a_16612_18504# VDD.t2051 pfet_05v0 ad=0.5368p pd=3.32u as=0.5368p ps=3.32u w=1.22u l=1u
X1404 a_8188_1592# a_8100_1636# VSS VSS nfet_05v0 ad=0.3608p pd=2.52u as=0.3608p ps=2.52u w=0.82u l=1u
X1405 a_8860_6296# a_8772_6340# VSS VSS nfet_05v0 ad=0.3608p pd=2.52u as=0.3608p ps=2.52u w=0.82u l=1u
X1406 VSS a_6051_18100# a_6051_18100# VSS nfet_05v0 ad=0.3608p pd=2.52u as=0.3608p ps=2.52u w=0.82u l=0.6u
X1407 a_1916_4728# a_1828_4772# VSS VSS nfet_05v0 ad=0.3608p pd=2.52u as=0.3608p ps=2.52u w=0.82u l=1u
X1408 a_9868_10567# a_9780_10664# VSS VSS nfet_05v0 ad=0.3608p pd=2.52u as=0.3608p ps=2.52u w=0.82u l=1u
X1409 a_17708_2727# a_17620_2824# VSS VSS nfet_05v0 ad=0.3608p pd=2.52u as=0.3608p ps=2.52u w=0.82u l=1u
X1410 VDD.t124 a_7628_7431# a_7540_7528# VDD.t123 pfet_05v0 ad=0.5368p pd=3.32u as=0.5368p ps=3.32u w=1.22u l=1u
X1411 a_5052_9432# a_4964_9476# VSS VSS nfet_05v0 ad=0.3608p pd=2.52u as=0.3608p ps=2.52u w=0.82u l=1u
X1412 a_5052_6296# a_4964_6340# VSS VSS nfet_05v0 ad=0.3608p pd=2.52u as=0.3608p ps=2.52u w=0.82u l=1u
X1413 a_1468_16839# a_1380_16936# VSS VSS nfet_05v0 ad=0.3608p pd=2.52u as=0.3608p ps=2.52u w=0.82u l=1u
X1414 VDD.t765 a_19948_15704# a_19860_15748# VDD.t764 pfet_05v0 ad=0.5368p pd=3.32u as=0.5368p ps=3.32u w=1.22u l=1u
X1415 a_17148_18407# a_17060_18504# VSS VSS nfet_05v0 ad=0.3608p pd=2.52u as=0.3608p ps=2.52u w=0.82u l=1u
X1416 ana_div_chain\[1\]_inv_notouch_.ZN wire18.I VDD.t1040 VDD.t1039 pfet_05v0 ad=0.5368p pd=3.32u as=0.5368p ps=3.32u w=1.22u l=0.5u
X1417 VDD.t1412 a_18492_14136# a_18404_14180# VDD.t1411 pfet_05v0 ad=0.5368p pd=3.32u as=0.5368p ps=3.32u w=1.22u l=1u
X1418 a_16784_16991# a_16352_16936# VDD.t1711 VDD.t1710 pfet_05v0 ad=54f pd=0.66u as=0.4554p ps=3.25u w=0.36u l=0.5u
X1419 VDD.t1311 a_18492_11000# a_18404_11044# VDD.t1310 pfet_05v0 ad=0.5368p pd=3.32u as=0.5368p ps=3.32u w=1.22u l=1u
X1420 VDD.t115 a_7180_4295# a_7092_4392# VDD.t114 pfet_05v0 ad=0.5368p pd=3.32u as=0.5368p ps=3.32u w=1.22u l=1u
X1421 VDD.t1290 a_15468_11000# a_15380_11044# VDD.t1289 pfet_05v0 ad=0.5368p pd=3.32u as=0.5368p ps=3.32u w=1.22u l=1u
X1422 a_9076_12287# a_7764_11911# a_8732_11919# VDD.t1668 pfet_05v0 ad=43.2f pd=0.6u as=0.1872p ps=1.4u w=0.36u l=0.5u
X1423 a_20620_8999# a_20532_9096# VSS VSS nfet_05v0 ad=0.3608p pd=2.52u as=0.3608p ps=2.52u w=0.82u l=1u
X1424 VDD.t1100 a_5276_18407# a_5188_18504# VDD.t1099 pfet_05v0 ad=0.5368p pd=3.32u as=0.5368p ps=3.32u w=1.22u l=1u
X1425 a_20620_5863# a_20532_5960# VSS VSS nfet_05v0 ad=0.3608p pd=2.52u as=0.3608p ps=2.52u w=0.82u l=1u
X1426 VSS a_20755_808# input1.Z VSS nfet_05v0 ad=0.28262p pd=1.87u as=0.3608p ps=2.52u w=0.82u l=0.6u
X1427 VDD.t1739 a_1916_7864# a_1828_7908# VDD.t1738 pfet_05v0 ad=0.5368p pd=3.32u as=0.5368p ps=3.32u w=1.22u l=1u
X1428 VDD.t1937 a_3260_12568# a_3172_12612# VDD.t1936 pfet_05v0 ad=0.5368p pd=3.32u as=0.5368p ps=3.32u w=1.22u l=1u
X1429 VDD.t503 a_5388_5863# a_5300_5960# VDD.t502 pfet_05v0 ad=0.5368p pd=3.32u as=0.5368p ps=3.32u w=1.22u l=1u
X1430 VDD.t1056 a_10204_15704# a_10116_15748# VDD.t1055 pfet_05v0 ad=0.5368p pd=3.32u as=0.5368p ps=3.32u w=1.22u l=1u
X1431 VDD.t1305 a_12780_8999# a_12692_9096# VDD.t1304 pfet_05v0 ad=0.5368p pd=3.32u as=0.5368p ps=3.32u w=1.22u l=1u
X1432 VDD.t9 a_5388_2727# a_5300_2824# VDD.t8 pfet_05v0 ad=0.5368p pd=3.32u as=0.5368p ps=3.32u w=1.22u l=1u
X1433 VDD.t1725 a_11548_4728# a_11460_4772# VDD.t1724 pfet_05v0 ad=0.5368p pd=3.32u as=0.5368p ps=3.32u w=1.22u l=1u
X1434 VDD.t1957 a_2364_7431# a_2276_7528# VDD.t1736 pfet_05v0 ad=0.5368p pd=3.32u as=0.5368p ps=3.32u w=1.22u l=1u
X1435 VDD.t240 a_11548_1592# a_11460_1636# VDD.t239 pfet_05v0 ad=0.5368p pd=3.32u as=0.5368p ps=3.32u w=1.22u l=1u
X1436 a_17260_12135# a_17172_12232# VSS VSS nfet_05v0 ad=0.3608p pd=2.52u as=0.3608p ps=2.52u w=0.82u l=1u
X1437 a_1020_17272# a_932_17316# VSS VSS nfet_05v0 ad=0.3608p pd=2.52u as=0.3608p ps=2.52u w=0.82u l=1u
X1438 a_15916_7431# a_15828_7528# VSS VSS nfet_05v0 ad=0.3608p pd=2.52u as=0.3608p ps=2.52u w=0.82u l=1u
X1439 a_7964_18407# a_7876_18504# VSS VSS nfet_05v0 ad=0.3608p pd=2.52u as=0.3608p ps=2.52u w=0.82u l=1u
X1440 VDD.t2076 a_8076_13703# a_7988_13800# VDD.t2075 pfet_05v0 ad=0.5368p pd=3.32u as=0.5368p ps=3.32u w=1.22u l=1u
X1441 VDD.t366 a_10764_5863# a_10676_5960# VDD.t365 pfet_05v0 ad=0.5368p pd=3.32u as=0.5368p ps=3.32u w=1.22u l=1u
X1442 VDD.t1009 a_9868_18407# a_9780_18504# VDD.t1008 pfet_05v0 ad=0.5368p pd=3.32u as=0.5368p ps=3.32u w=1.22u l=1u
X1443 a_1020_3160# a_932_3204# VSS VSS nfet_05v0 ad=0.3608p pd=2.52u as=0.3608p ps=2.52u w=0.82u l=1u
X1444 VDD.t848 a_21964_12135# a_21876_12232# VDD.t847 pfet_05v0 ad=0.5368p pd=3.32u as=0.5368p ps=3.32u w=1.22u l=1u
X1445 VDD.t888 a_10764_2727# a_10676_2824# VDD.t887 pfet_05v0 ad=0.5368p pd=3.32u as=0.5368p ps=3.32u w=1.22u l=1u
X1446 VDD.t1138 a_18044_6296# a_17956_6340# VDD.t1137 pfet_05v0 ad=0.5368p pd=3.32u as=0.5368p ps=3.32u w=1.22u l=1u
X1447 dvo[1].t2 a_14708_12612# VSS VSS nfet_05v0 ad=0.3608p pd=2.52u as=0.2132p ps=1.34u w=0.82u l=0.6u
X1448 VDD.t890 a_18044_3160# a_17956_3204# VDD.t889 pfet_05v0 ad=0.5368p pd=3.32u as=0.5368p ps=3.32u w=1.22u l=1u
X1449 a_6396_12568# a_6308_12612# VSS VSS nfet_05v0 ad=0.3608p pd=2.52u as=0.3608p ps=2.52u w=0.82u l=1u
X1450 VDD.t1188 a_21516_4295# a_21428_4392# VDD.t1187 pfet_05v0 ad=0.5368p pd=3.32u as=0.5368p ps=3.32u w=1.22u l=1u
X1451 VDD.t1618 a_15468_8999# a_15380_9096# VDD.t1617 pfet_05v0 ad=0.5368p pd=3.32u as=0.5368p ps=3.32u w=1.22u l=1u
X1452 a_12108_7431# a_12020_7528# VSS VSS nfet_05v0 ad=0.3608p pd=2.52u as=0.3608p ps=2.52u w=0.82u l=1u
X1453 VDD.t1974 a_14432_11875# a_14392_12243# VDD.t1973 pfet_05v0 ad=0.2249p pd=1.385u as=0.3806p ps=2.61u w=0.865u l=0.5u
X1454 a_12220_14136# a_12132_14180# VSS VSS nfet_05v0 ad=0.3608p pd=2.52u as=0.3608p ps=2.52u w=0.82u l=1u
X1455 VDD.t1238 a_4156_4728# a_4068_4772# VDD.t26 pfet_05v0 ad=0.5368p pd=3.32u as=0.5368p ps=3.32u w=1.22u l=1u
X1456 ana_div_chain\[2\]_inv_notouch_.ZN ana_div_chain\[2\]_inv_notouch_.I VSS VSS nfet_05v0 ad=0.3608p pd=2.52u as=0.3608p ps=2.52u w=0.82u l=0.6u
X1457 a_18828_15271# a_18740_15368# VSS VSS nfet_05v0 ad=0.3608p pd=2.52u as=0.3608p ps=2.52u w=0.82u l=1u
X1458 VDD.t1853 a_4156_1592# a_4068_1636# VDD.t289 pfet_05v0 ad=0.5368p pd=3.32u as=0.5368p ps=3.32u w=1.22u l=1u
X1459 VDD.t566 ana_div_chain\[3\]_inv_notouch_.I a_16612_17316# VDD.t565 pfet_05v0 ad=0.4941p pd=2.03u as=0.5368p ps=3.32u w=1.22u l=0.5u
X1460 a_19388_7864# a_19300_7908# VSS VSS nfet_05v0 ad=0.3608p pd=2.52u as=0.3608p ps=2.52u w=0.82u l=1u
X1461 a_15848_17776# avo[4].t7 VSS VSS nfet_05v0 ad=0.1584p pd=1.6u as=0.153p ps=1.195u w=0.36u l=0.6u
X1462 a_19388_4728# a_19300_4772# VSS VSS nfet_05v0 ad=0.3608p pd=2.52u as=0.3608p ps=2.52u w=0.82u l=1u
X1463 VDD.t1566 a_20662_13352# avo[1].t5 VDD.t1565 pfet_05v0 ad=0.4941p pd=2.03u as=0.3782p ps=1.84u w=1.22u l=0.5u
X1464 a_13676_2727# a_13588_2824# VSS VSS nfet_05v0 ad=0.3608p pd=2.52u as=0.3608p ps=2.52u w=0.82u l=1u
X1465 dvo[5].t4 a_12038_17744# VDD.t1153 VDD.t1152 pfet_05v0 ad=0.3782p pd=1.84u as=0.3782p ps=1.84u w=1.22u l=0.5u
X1466 VDD.t316 a_16611_808# input2.Z VDD.t315 pfet_05v0 ad=0.379p pd=2.37u as=0.5368p ps=3.32u w=1.22u l=0.5u
X1467 a_8524_7431# a_8436_7528# VSS VSS nfet_05v0 ad=0.3608p pd=2.52u as=0.3608p ps=2.52u w=0.82u l=1u
X1468 a_6284_13703# a_6196_13800# VSS VSS nfet_05v0 ad=0.3608p pd=2.52u as=0.3608p ps=2.52u w=0.82u l=1u
X1469 a_21740_13703# a_21652_13800# VSS VSS nfet_05v0 ad=0.3608p pd=2.52u as=0.3608p ps=2.52u w=0.82u l=1u
X1470 a_14236_1592# a_14148_1636# VSS VSS nfet_05v0 ad=0.3608p pd=2.52u as=0.3608p ps=2.52u w=0.82u l=1u
X1471 VDD.t1360 a_6396_15704# a_6308_15748# VDD.t1359 pfet_05v0 ad=0.5368p pd=3.32u as=0.5368p ps=3.32u w=1.22u l=1u
X1472 VDD.t1840 a_8076_8999# a_7988_9096# VDD.t1839 pfet_05v0 ad=0.5368p pd=3.32u as=0.5368p ps=3.32u w=1.22u l=1u
X1473 VDD.t1023 a_18156_12135# a_18068_12232# VDD.t1022 pfet_05v0 ad=0.5368p pd=3.32u as=0.5368p ps=3.32u w=1.22u l=1u
X1474 VDD.t556 a_5836_16839# a_5748_16936# VDD.t555 pfet_05v0 ad=0.5368p pd=3.32u as=0.5368p ps=3.32u w=1.22u l=1u
X1475 a_14348_9432# a_14260_9476# VSS VSS nfet_05v0 ad=0.3608p pd=2.52u as=0.3608p ps=2.52u w=0.82u l=1u
X1476 VDD.t1923 a_9868_5863# a_9780_5960# VDD.t1922 pfet_05v0 ad=0.5368p pd=3.32u as=0.5368p ps=3.32u w=1.22u l=1u
X1477 avo[4].t5 a_16612_17316# VDD.t1708 VDD.t1707 pfet_05v0 ad=0.5368p pd=3.32u as=0.3782p ps=1.84u w=1.22u l=0.5u
X1478 VDD.t362 a_9868_2727# a_9780_2824# VDD.t361 pfet_05v0 ad=0.5368p pd=3.32u as=0.5368p ps=3.32u w=1.22u l=1u
X1479 a_11100_9432# a_11012_9476# VSS VSS nfet_05v0 ad=0.3608p pd=2.52u as=0.3608p ps=2.52u w=0.82u l=1u
X1480 a_18044_12568# a_17956_12612# VSS VSS nfet_05v0 ad=0.3608p pd=2.52u as=0.3608p ps=2.52u w=0.82u l=1u
X1481 a_15020_8999# a_14932_9096# VSS VSS nfet_05v0 ad=0.3608p pd=2.52u as=0.3608p ps=2.52u w=0.82u l=1u
X1482 a_4940_4295# a_4852_4392# VSS VSS nfet_05v0 ad=0.3608p pd=2.52u as=0.3608p ps=2.52u w=0.82u l=1u
X1483 a_11100_6296# a_11012_6340# VSS VSS nfet_05v0 ad=0.3608p pd=2.52u as=0.3608p ps=2.52u w=0.82u l=1u
X1484 a_15020_5863# a_14932_5960# VSS VSS nfet_05v0 ad=0.3608p pd=2.52u as=0.3608p ps=2.52u w=0.82u l=1u
X1485 VDD.t1346 a_20732_17272# a_20644_17316# VDD.t1345 pfet_05v0 ad=0.5368p pd=3.32u as=0.5368p ps=3.32u w=1.22u l=1u
X1486 VDD.t791 a_19388_7864# a_19300_7908# VDD.t790 pfet_05v0 ad=0.5368p pd=3.32u as=0.5368p ps=3.32u w=1.22u l=1u
X1487 a_6284_2727# a_6196_2824# VSS VSS nfet_05v0 ad=0.3608p pd=2.52u as=0.3608p ps=2.52u w=0.82u l=1u
X1488 a_3260_7431# a_3172_7528# VSS VSS nfet_05v0 ad=0.3608p pd=2.52u as=0.3608p ps=2.52u w=0.82u l=1u
X1489 VDD.t1324 a_2364_9432# a_2276_9476# VDD.t1162 pfet_05v0 ad=0.5368p pd=3.32u as=0.5368p ps=3.32u w=1.22u l=1u
X1490 a_5500_3160# a_5412_3204# VSS VSS nfet_05v0 ad=0.3608p pd=2.52u as=0.3608p ps=2.52u w=0.82u l=1u
X1491 a_12892_6296# a_12804_6340# VSS VSS nfet_05v0 ad=0.3608p pd=2.52u as=0.3608p ps=2.52u w=0.82u l=1u
X1492 VDD.t1110 a_15468_16839# a_15380_16936# VDD.t1109 pfet_05v0 ad=0.5368p pd=3.32u as=0.5368p ps=3.32u w=1.22u l=1u
X1493 VDD.t2042 a_12780_13703# a_12692_13800# VDD.t2041 pfet_05v0 ad=0.5368p pd=3.32u as=0.5368p ps=3.32u w=1.22u l=1u
X1494 VDD.t536 a_19948_8999# a_19860_9096# VDD.t535 pfet_05v0 ad=0.5368p pd=3.32u as=0.5368p ps=3.32u w=1.22u l=1u
X1495 a_19836_17272# a_19748_17316# VSS VSS nfet_05v0 ad=0.3608p pd=2.52u as=0.3608p ps=2.52u w=0.82u l=1u
X1496 VDD.t2002 a_20284_6296# a_20196_6340# VDD.t2001 pfet_05v0 ad=0.5368p pd=3.32u as=0.5368p ps=3.32u w=1.22u l=1u
X1497 a_12444_18407# a_12356_18504# VSS VSS nfet_05v0 ad=0.3608p pd=2.52u as=0.3608p ps=2.52u w=0.82u l=1u
X1498 VDD.t294 a_20284_3160# a_20196_3204# VDD.t293 pfet_05v0 ad=0.5368p pd=3.32u as=0.5368p ps=3.32u w=1.22u l=1u
X1499 a_11660_2727# a_11572_2824# VSS VSS nfet_05v0 ad=0.3608p pd=2.52u as=0.3608p ps=2.52u w=0.82u l=1u
X1500 a_7628_4295# a_7540_4392# VSS VSS nfet_05v0 ad=0.3608p pd=2.52u as=0.3608p ps=2.52u w=0.82u l=1u
X1501 VSS a_13272_13352# wire20.I VSS nfet_05v0 ad=0.3608p pd=2.52u as=0.2132p ps=1.34u w=0.82u l=0.6u
X1502 VDD.t1007 a_14124_10567# a_14036_10664# VDD.t1006 pfet_05v0 ad=0.5368p pd=3.32u as=0.5368p ps=3.32u w=1.22u l=1u
X1503 a_14776_11919# a_14432_11875# a_13988_12071# VDD.t1971 pfet_05v0 ad=0.1791p pd=1.355u as=0.1665p ps=1.285u w=0.36u l=0.5u
X1504 a_13072_13097# a_12536_13097# VSS VSS nfet_05v0 ad=43.2f pd=0.6u as=0.2637p ps=1.825u w=0.36u l=0.6u
X1505 a_7292_15704# a_7204_15748# VSS VSS nfet_05v0 ad=0.3608p pd=2.52u as=0.3608p ps=2.52u w=0.82u l=1u
X1506 a_14320_13443# input2.Z VSS VSS nfet_05v0 ad=0.1782p pd=1.69u as=0.1053p ps=0.925u w=0.405u l=0.6u
X1507 VDD.t1784 a_3708_6296# a_3620_6340# VDD.t106 pfet_05v0 ad=0.5368p pd=3.32u as=0.5368p ps=3.32u w=1.22u l=1u
X1508 a_13168_16189# a_12875_15865# VDD.t1362 VDD.t1361 pfet_05v0 ad=0.352p pd=2.48u as=0.23p ps=1.54u w=0.8u l=0.5u
X1509 VDD.t783 a_3708_3160# a_3620_3204# VDD.t782 pfet_05v0 ad=0.5368p pd=3.32u as=0.5368p ps=3.32u w=1.22u l=1u
X1510 a_9840_13855# a_9408_13800# VDD.t1279 VDD.t1278 pfet_05v0 ad=54f pd=0.66u as=0.4554p ps=3.25u w=0.36u l=0.5u
X1511 VDD.t1270 a_9084_1159# a_8996_1256# VDD.t1269 pfet_05v0 ad=0.5368p pd=3.32u as=0.5368p ps=3.32u w=1.22u l=1u
X1512 a_16812_10567# a_16724_10664# VSS VSS nfet_05v0 ad=0.3608p pd=2.52u as=0.3608p ps=2.52u w=0.82u l=1u
X1513 a_7180_16839# a_7092_16936# VSS VSS nfet_05v0 ad=0.3608p pd=2.52u as=0.3608p ps=2.52u w=0.82u l=1u
X1514 VDD.t615 a_17148_13703# a_17060_13800# VDD.t474 pfet_05v0 ad=0.5368p pd=3.32u as=0.5368p ps=3.32u w=1.22u l=1u
X1515 VSS a_11748_12568# a_11144_12971# VSS nfet_05v0 ad=0.142p pd=1.14u as=0.176p ps=1.68u w=0.4u l=0.6u
X1516 a_4156_16839# a_4068_16936# VSS VSS nfet_05v0 ad=0.3608p pd=2.52u as=0.3608p ps=2.52u w=0.82u l=1u
X1517 a_2364_4295# a_2276_4392# VSS VSS nfet_05v0 ad=0.3608p pd=2.52u as=0.3608p ps=2.52u w=0.82u l=1u
X1518 ana_div_chain\[3\]_inv_notouch_.ZN ana_div_chain\[3\]_inv_notouch_.I VDD.t564 VDD.t563 pfet_05v0 ad=0.5368p pd=3.32u as=0.5368p ps=3.32u w=1.22u l=0.5u
X1519 VDD.t43 a_10204_4728# a_10116_4772# VDD.t42 pfet_05v0 ad=0.5368p pd=3.32u as=0.5368p ps=3.32u w=1.22u l=1u
X1520 VDD.t937 a_1020_7431# a_932_7528# VDD.t936 pfet_05v0 ad=0.5368p pd=3.32u as=0.5368p ps=3.32u w=1.22u l=1u
X1521 a_19500_8999# a_19412_9096# VSS VSS nfet_05v0 ad=0.3608p pd=2.52u as=0.3608p ps=2.52u w=0.82u l=1u
X1522 VDD.t292 a_10204_1592# a_10116_1636# VDD.t291 pfet_05v0 ad=0.5368p pd=3.32u as=0.5368p ps=3.32u w=1.22u l=1u
X1523 VDD.t1406 a_4940_10567# a_4852_10664# VDD.t1405 pfet_05v0 ad=0.5368p pd=3.32u as=0.5368p ps=3.32u w=1.22u l=1u
X1524 VDD.t1200 a_21516_16839# a_21428_16936# VDD.t1199 pfet_05v0 ad=0.5368p pd=3.32u as=0.5368p ps=3.32u w=1.22u l=1u
X1525 VDD.t1321 a_8860_15704# a_8772_15748# VDD.t1320 pfet_05v0 ad=0.5368p pd=3.32u as=0.5368p ps=3.32u w=1.22u l=1u
X1526 a_19500_5863# a_19412_5960# VSS VSS nfet_05v0 ad=0.3608p pd=2.52u as=0.3608p ps=2.52u w=0.82u l=1u
X1527 a_8188_9432# a_8100_9476# VSS VSS nfet_05v0 ad=0.3608p pd=2.52u as=0.3608p ps=2.52u w=0.82u l=1u
X1528 VDD.t560 a_1916_10567# a_1828_10664# VDD.t559 pfet_05v0 ad=0.5368p pd=3.32u as=0.5368p ps=3.32u w=1.22u l=1u
X1529 VDD.t2046 a_10316_16839# a_10228_16936# VDD.t2045 pfet_05v0 ad=0.5368p pd=3.32u as=0.5368p ps=3.32u w=1.22u l=1u
X1530 a_8188_6296# a_8100_6340# VSS VSS nfet_05v0 ad=0.3608p pd=2.52u as=0.3608p ps=2.52u w=0.82u l=1u
X1531 a_9104_11875# a_8732_11919# VDD.t1530 VDD.t1529 pfet_05v0 ad=0.1791p pd=1.355u as=0.1044p ps=0.94u w=0.36u l=0.5u
X1532 VDD.t1777 a_11996_4728# a_11908_4772# VDD.t1776 pfet_05v0 ad=0.5368p pd=3.32u as=0.5368p ps=3.32u w=1.22u l=1u
X1533 VDD.t687 a_6844_9432# a_6756_9476# VDD.t686 pfet_05v0 ad=0.5368p pd=3.32u as=0.5368p ps=3.32u w=1.22u l=1u
X1534 a_9868_15271# a_9780_15368# VSS VSS nfet_05v0 ad=0.3608p pd=2.52u as=0.3608p ps=2.52u w=0.82u l=1u
X1535 a_3260_14136# a_3172_14180# VSS VSS nfet_05v0 ad=0.3608p pd=2.52u as=0.3608p ps=2.52u w=0.82u l=1u
X1536 VSS a_20662_13352# avo[1].t0 VSS nfet_05v0 ad=0.2132p pd=1.34u as=0.3608p ps=2.52u w=0.82u l=0.6u
X1537 VDD.t1265 a_11996_1592# a_11908_1636# VDD.t1264 pfet_05v0 ad=0.5368p pd=3.32u as=0.5368p ps=3.32u w=1.22u l=1u
X1538 a_13280_11485# a_12987_11161# VDD.t438 VDD.t437 pfet_05v0 ad=0.352p pd=2.48u as=0.23p ps=1.54u w=0.8u l=0.5u
X1539 a_3260_11000# a_3172_11044# VSS VSS nfet_05v0 ad=0.3608p pd=2.52u as=0.3608p ps=2.52u w=0.82u l=1u
X1540 VDD.t841 a_7740_17272# a_7652_17316# VDD.t840 pfet_05v0 ad=0.5368p pd=3.32u as=0.5368p ps=3.32u w=1.22u l=1u
X1541 a_11700_16233# a_10900_16232# VSS VSS nfet_05v0 ad=43.2f pd=0.6u as=0.1584p ps=1.6u w=0.36u l=0.6u
X1542 a_11548_3160# a_11460_3204# VSS VSS nfet_05v0 ad=0.3608p pd=2.52u as=0.3608p ps=2.52u w=0.82u l=1u
X1543 VDD.t1612 a_14124_8999# a_14036_9096# VDD.t1611 pfet_05v0 ad=0.5368p pd=3.32u as=0.5368p ps=3.32u w=1.22u l=1u
X1544 a_5388_10567# a_5300_10664# VSS VSS nfet_05v0 ad=0.3608p pd=2.52u as=0.3608p ps=2.52u w=0.82u l=1u
X1545 a_12892_18407# a_12804_18504# VSS VSS nfet_05v0 ad=0.3608p pd=2.52u as=0.3608p ps=2.52u w=0.82u l=1u
X1546 VDD.t144 a_15916_5863# a_15828_5960# VDD.t143 pfet_05v0 ad=0.5368p pd=3.32u as=0.5368p ps=3.32u w=1.22u l=1u
X1547 dac_div_chain\[4\]_inv_notouch_.I a_11796_16577# VDD.t761 VDD.t760 pfet_05v0 ad=0.5368p pd=3.32u as=0.4015p ps=1.92u w=1.22u l=0.5u
X1548 VDD.t1893 a_15916_2727# a_15828_2824# VDD.t1892 pfet_05v0 ad=0.5368p pd=3.32u as=0.5368p ps=3.32u w=1.22u l=1u
X1549 VDD.t1005 a_14572_10567# a_14484_10664# VDD.t1004 pfet_05v0 ad=0.5368p pd=3.32u as=0.5368p ps=3.32u w=1.22u l=1u
X1550 VDD.t1088 a_18492_6296# a_18404_6340# VDD.t1087 pfet_05v0 ad=0.5368p pd=3.32u as=0.5368p ps=3.32u w=1.22u l=1u
X1551 VDD.t1863 dvo[5].t7 a_11796_16577# VDD.t1862 pfet_05v0 ad=0.4015p pd=1.92u as=0.462p ps=2.98u w=1.05u l=0.5u
X1552 VDD.t3 a_18492_3160# a_18404_3204# VDD.t2 pfet_05v0 ad=0.5368p pd=3.32u as=0.5368p ps=3.32u w=1.22u l=1u
X1553 VDD.t2026 a_21964_4295# a_21876_4392# VDD.t2025 pfet_05v0 ad=0.5368p pd=3.32u as=0.5368p ps=3.32u w=1.22u l=1u
X1554 a_20662_13352# ana_div_chain\[0\]_dff_notouch_.Q VSS VSS nfet_05v0 ad=0.3608p pd=2.52u as=0.2911p ps=1.53u w=0.82u l=0.6u
X1555 a_18044_7864# a_17956_7908# VSS VSS nfet_05v0 ad=0.3608p pd=2.52u as=0.3608p ps=2.52u w=0.82u l=1u
X1556 a_16700_1592# a_16612_1636# VSS VSS nfet_05v0 ad=0.3608p pd=2.52u as=0.3608p ps=2.52u w=0.82u l=1u
X1557 a_18044_4728# a_17956_4772# VSS VSS nfet_05v0 ad=0.3608p pd=2.52u as=0.3608p ps=2.52u w=0.82u l=1u
X1558 VDD.t304 a_12108_5863# a_12020_5960# VDD.t303 pfet_05v0 ad=0.5368p pd=3.32u as=0.5368p ps=3.32u w=1.22u l=1u
X1559 VDD.t956 a_20896_13053# ana_div_chain\[0\]_dff_notouch_.Q VDD.t955 pfet_05v0 ad=0.854p pd=3.84u as=0.3172p ps=1.74u w=1.22u l=0.5u
X1560 VDD.t1342 a_5948_14136# a_5860_14180# VDD.t1341 pfet_05v0 ad=0.5368p pd=3.32u as=0.5368p ps=3.32u w=1.22u l=1u
X1561 VDD.t302 a_12108_2727# a_12020_2824# VDD.t301 pfet_05v0 ad=0.5368p pd=3.32u as=0.5368p ps=3.32u w=1.22u l=1u
X1562 VDD.t1753 a_9308_4728# a_9220_4772# VDD.t1752 pfet_05v0 ad=0.5368p pd=3.32u as=0.5368p ps=3.32u w=1.22u l=1u
X1563 VDD.t964 a_2364_15271# a_2276_15368# VDD.t963 pfet_05v0 ad=0.5368p pd=3.32u as=0.5368p ps=3.32u w=1.22u l=1u
X1564 VDD.t1796 a_9308_1592# a_9220_1636# VDD.t1795 pfet_05v0 ad=0.5368p pd=3.32u as=0.5368p ps=3.32u w=1.22u l=1u
X1565 VDD.t394 a_5948_11000# a_5860_11044# VDD.t393 pfet_05v0 ad=0.5368p pd=3.32u as=0.5368p ps=3.32u w=1.22u l=1u
X1566 a_17752_18101# avo[5].t6 VSS VSS nfet_05v0 ad=0.1584p pd=1.6u as=0.153p ps=1.195u w=0.36u l=0.6u
X1567 VDD.t1136 a_14880_11875# a_14776_11919# VDD.t1135 pfet_05v0 ad=0.1044p pd=0.94u as=0.1791p ps=1.355u w=0.36u l=0.5u
X1568 VSS a_10419_18100# a_10419_18100# VSS nfet_05v0 ad=0.3608p pd=2.52u as=0.3608p ps=2.52u w=0.82u l=0.6u
X1569 a_4156_3160# a_4068_3204# VSS VSS nfet_05v0 ad=0.3608p pd=2.52u as=0.3608p ps=2.52u w=0.82u l=1u
X1570 a_8972_7431# a_8884_7528# VSS VSS nfet_05v0 ad=0.3608p pd=2.52u as=0.3608p ps=2.52u w=0.82u l=1u
X1571 a_3708_15704# a_3620_15748# VSS VSS nfet_05v0 ad=0.3608p pd=2.52u as=0.3608p ps=2.52u w=0.82u l=1u
X1572 VDD.t1482 a_17596_13703# a_17508_13800# VDD.t472 pfet_05v0 ad=0.5368p pd=3.32u as=0.5368p ps=3.32u w=1.22u l=1u
X1573 a_13004_9432# a_12916_9476# VSS VSS nfet_05v0 ad=0.3608p pd=2.52u as=0.3608p ps=2.52u w=0.82u l=1u
X1574 VDD.t1901 a_8524_5863# a_8436_5960# VDD.t1900 pfet_05v0 ad=0.5368p pd=3.32u as=0.5368p ps=3.32u w=1.22u l=1u
X1575 VDD.t726 a_8524_2727# a_8436_2824# VDD.t725 pfet_05v0 ad=0.5368p pd=3.32u as=0.5368p ps=3.32u w=1.22u l=1u
X1576 VSS a_14320_13443# a_15692_13487# VSS nfet_05v0 ad=0.1584p pd=1.6u as=43.2f ps=0.6u w=0.36u l=0.6u
X1577 a_14684_1592# a_14596_1636# VSS VSS nfet_05v0 ad=0.3608p pd=2.52u as=0.3608p ps=2.52u w=0.82u l=1u
X1578 a_1916_8999# a_1828_9096# VSS VSS nfet_05v0 ad=0.3608p pd=2.52u as=0.3608p ps=2.52u w=0.82u l=1u
X1579 VDD.t2056 a_21964_16839# a_21876_16936# VDD.t2055 pfet_05v0 ad=0.5368p pd=3.32u as=0.5368p ps=3.32u w=1.22u l=1u
X1580 a_10336_13443# a_9964_13487# VDD.t932 VDD.t931 pfet_05v0 ad=0.1791p pd=1.355u as=0.1044p ps=0.94u w=0.36u l=0.5u
X1581 a_1916_5863# a_1828_5960# VSS VSS nfet_05v0 ad=0.3608p pd=2.52u as=0.3608p ps=2.52u w=0.82u l=1u
X1582 a_14796_9432# a_14708_9476# VSS VSS nfet_05v0 ad=0.3608p pd=2.52u as=0.3608p ps=2.52u w=0.82u l=1u
X1583 VDD.t2044 a_10764_16839# a_10676_16936# VDD.t2043 pfet_05v0 ad=0.5368p pd=3.32u as=0.5368p ps=3.32u w=1.22u l=1u
X1584 a_3260_10567# a_3172_10664# VSS VSS nfet_05v0 ad=0.3608p pd=2.52u as=0.3608p ps=2.52u w=0.82u l=1u
X1585 VSS a_8902_11472# dvo[3].t2 VSS nfet_05v0 ad=0.2911p pd=1.53u as=0.2132p ps=1.34u w=0.82u l=0.6u
X1586 VDD.t193 a_18044_7864# a_17956_7908# VDD.t192 pfet_05v0 ad=0.5368p pd=3.32u as=0.5368p ps=3.32u w=1.22u l=1u
X1587 a_19276_1159# a_19188_1256# VSS VSS nfet_05v0 ad=0.3608p pd=2.52u as=0.3608p ps=2.52u w=0.82u l=1u
X1588 VDD.t801 a_17148_12568# a_17060_12612# VDD.t800 pfet_05v0 ad=0.5368p pd=3.32u as=0.5368p ps=3.32u w=1.22u l=1u
X1589 VDD.t254 a_15132_1159# a_15044_1256# VDD.t253 pfet_05v0 ad=0.5368p pd=3.32u as=0.5368p ps=3.32u w=1.22u l=1u
X1590 a_13232_11529# a_11012_11528# a_12987_11161# VSS nfet_05v0 ad=43.2f pd=0.6u as=93.59999f ps=0.88u w=0.36u l=0.6u
X1591 a_12640_12932# a_12152_12637# a_13072_13097# VSS nfet_05v0 ad=0.207p pd=1.51u as=43.2f ps=0.6u w=0.36u l=0.6u
X1592 VDD.t813 a_1020_9432# a_932_9476# VDD.t812 pfet_05v0 ad=0.5368p pd=3.32u as=0.5368p ps=3.32u w=1.22u l=1u
X1593 VDD.t1634 a_8524_16839# a_8436_16936# VDD.t1633 pfet_05v0 ad=0.5368p pd=3.32u as=0.5368p ps=3.32u w=1.22u l=1u
X1594 VDD.t636 a_20620_10567# a_20532_10664# VDD.t635 pfet_05v0 ad=0.5368p pd=3.32u as=0.5368p ps=3.32u w=1.22u l=1u
X1595 VDD.t667 a_12152_12637# a_13508_12729# VDD.t666 pfet_05v0 ad=0.4554p pd=3.25u as=54f ps=0.66u w=0.36u l=0.5u
X1596 VDD.t920 a_2812_13703# a_2724_13800# VDD.t820 pfet_05v0 ad=0.5368p pd=3.32u as=0.5368p ps=3.32u w=1.22u l=1u
X1597 VDD.t1686 a_18604_8999# a_18516_9096# VDD.t1685 pfet_05v0 ad=0.5368p pd=3.32u as=0.5368p ps=3.32u w=1.22u l=1u
X1598 VDD.t1878 dac_div_chain\[1\]_inv_notouch_.I dac_div_chain\[1\]_inv_notouch_.ZN VDD.t1877 pfet_05v0 ad=0.5368p pd=3.32u as=0.5368p ps=3.32u w=1.22u l=0.5u
X1599 a_14664_13487# a_14280_13811# a_13876_13639# VSS nfet_05v0 ad=93.59999f pd=0.88u as=93.59999f ps=0.88u w=0.36u l=0.6u
X1600 VDD.t1517 a_10316_7431# a_10228_7528# VDD.t1516 pfet_05v0 ad=0.5368p pd=3.32u as=0.5368p ps=3.32u w=1.22u l=1u
X1601 VDD.t73 a_3260_5863# a_3172_5960# VDD.t72 pfet_05v0 ad=0.5368p pd=3.32u as=0.5368p ps=3.32u w=1.22u l=1u
X1602 VDD.t249 a_3260_2727# a_3172_2824# VDD.t248 pfet_05v0 ad=0.5368p pd=3.32u as=0.5368p ps=3.32u w=1.22u l=1u
X1603 a_7292_1592# a_7204_1636# VSS VSS nfet_05v0 ad=0.3608p pd=2.52u as=0.3608p ps=2.52u w=0.82u l=1u
X1604 a_21068_10567# a_20980_10664# VSS VSS nfet_05v0 ad=0.3608p pd=2.52u as=0.3608p ps=2.52u w=0.82u l=1u
X1605 a_18156_8999# a_18068_9096# VSS VSS nfet_05v0 ad=0.3608p pd=2.52u as=0.3608p ps=2.52u w=0.82u l=1u
X1606 a_14236_6296# a_14148_6340# VSS VSS nfet_05v0 ad=0.3608p pd=2.52u as=0.3608p ps=2.52u w=0.82u l=1u
X1607 a_13228_16839# a_13140_16936# VSS VSS nfet_05v0 ad=0.3608p pd=2.52u as=0.3608p ps=2.52u w=0.82u l=1u
X1608 a_16812_2727# a_16724_2824# VSS VSS nfet_05v0 ad=0.3608p pd=2.52u as=0.3608p ps=2.52u w=0.82u l=1u
X1609 a_18156_5863# a_18068_5960# VSS VSS nfet_05v0 ad=0.3608p pd=2.52u as=0.3608p ps=2.52u w=0.82u l=1u
X1610 VDD.t730 a_20755_808# input1.Z VDD.t729 pfet_05v0 ad=0.379p pd=2.37u as=0.5368p ps=3.32u w=1.22u l=0.5u
X1611 VDD.t207 a_6732_7431# a_6644_7528# VDD.t206 pfet_05v0 ad=0.5368p pd=3.32u as=0.5368p ps=3.32u w=1.22u l=1u
X1612 a_20284_7864# a_20196_7908# VSS VSS nfet_05v0 ad=0.3608p pd=2.52u as=0.3608p ps=2.52u w=0.82u l=1u
X1613 a_20284_4728# a_20196_4772# VSS VSS nfet_05v0 ad=0.3608p pd=2.52u as=0.3608p ps=2.52u w=0.82u l=1u
X1614 a_15132_18407# a_15044_18504# VSS VSS nfet_05v0 ad=0.3608p pd=2.52u as=0.3608p ps=2.52u w=0.82u l=1u
X1615 a_14728_14640# dvo[1].t6 VDD.t160 VDD.t159 pfet_05v0 ad=0.462p pd=2.98u as=0.4015p ps=1.92u w=1.05u l=0.5u
X1616 a_13228_7431# a_13140_7528# VSS VSS nfet_05v0 ad=0.3608p pd=2.52u as=0.3608p ps=2.52u w=0.82u l=1u
X1617 a_20396_15704# a_20308_15748# VSS VSS nfet_05v0 ad=0.3608p pd=2.52u as=0.3608p ps=2.52u w=0.82u l=1u
X1618 VDD.t1640 a_14908_15704# a_14820_15748# VDD.t1639 pfet_05v0 ad=0.5368p pd=3.32u as=0.5368p ps=3.32u w=1.22u l=1u
X1619 VDD.t1128 a_16364_4295# a_16276_4392# VDD.t1127 pfet_05v0 ad=0.5368p pd=3.32u as=0.5368p ps=3.32u w=1.22u l=1u
X1620 avo[2].t3 a_11366_10216# VSS VSS nfet_05v0 ad=0.2132p pd=1.34u as=0.2132p ps=1.34u w=0.82u l=0.6u
X1621 VSS input1.Z a_20420_14180# VSS nfet_05v0 ad=0.2911p pd=1.53u as=0.3608p ps=2.52u w=0.82u l=0.6u
X1622 a_3708_7864# a_3620_7908# VSS VSS nfet_05v0 ad=0.3608p pd=2.52u as=0.3608p ps=2.52u w=0.82u l=1u
X1623 VDD.t1622 a_21628_11000# a_21540_11044# VDD.t1621 pfet_05v0 ad=0.5368p pd=3.32u as=0.5368p ps=3.32u w=1.22u l=1u
X1624 a_3708_4728# a_3620_4772# VSS VSS nfet_05v0 ad=0.3608p pd=2.52u as=0.3608p ps=2.52u w=0.82u l=1u
X1625 a_1020_4295# a_932_4392# VSS VSS nfet_05v0 ad=0.3608p pd=2.52u as=0.3608p ps=2.52u w=0.82u l=1u
X1626 a_21205_852# a_21085_808# VSS VSS nfet_05v0 ad=43.8f pd=0.605u as=0.28262p ps=1.87u w=0.365u l=0.6u
X1627 VDD.t525 a_19968_13053# a_19940_12729# VDD.t524 pfet_05v0 ad=0.1044p pd=0.94u as=43.2f ps=0.6u w=0.36u l=0.5u
X1628 a_11312_15819# a_10900_16232# VSS VSS nfet_05v0 ad=0.1782p pd=1.69u as=0.1053p ps=0.925u w=0.405u l=0.6u
X1629 avo[2].t1 a_11366_10216# VDD.t941 VDD.t940 pfet_05v0 ad=0.3782p pd=1.84u as=0.3782p ps=1.84u w=1.22u l=0.5u
X1630 a_9420_2727# a_9332_2824# VSS VSS nfet_05v0 ad=0.3608p pd=2.52u as=0.3608p ps=2.52u w=0.82u l=1u
X1631 a_21628_1592# a_21540_1636# VSS VSS nfet_05v0 ad=0.3608p pd=2.52u as=0.3608p ps=2.52u w=0.82u l=1u
X1632 VDD.t799 a_17596_12568# a_17508_12612# VDD.t798 pfet_05v0 ad=0.5368p pd=3.32u as=0.5368p ps=3.32u w=1.22u l=1u
X1633 VDD.t1237 a_10652_4728# a_10564_4772# VDD.t1236 pfet_05v0 ad=0.5368p pd=3.32u as=0.5368p ps=3.32u w=1.22u l=1u
X1634 VDD.t1556 a_5500_9432# a_5412_9476# VDD.t1555 pfet_05v0 ad=0.5368p pd=3.32u as=0.5368p ps=3.32u w=1.22u l=1u
X1635 VDD.t1632 a_8972_16839# a_8884_16936# VDD.t1631 pfet_05v0 ad=0.5368p pd=3.32u as=0.5368p ps=3.32u w=1.22u l=1u
X1636 VDD.t1852 a_10652_1592# a_10564_1636# VDD.t1851 pfet_05v0 ad=0.5368p pd=3.32u as=0.5368p ps=3.32u w=1.22u l=1u
X1637 a_19500_10567# a_19412_10664# VSS VSS nfet_05v0 ad=0.3608p pd=2.52u as=0.3608p ps=2.52u w=0.82u l=1u
X1638 VDD.t1931 a_20284_7864# a_20196_7908# VDD.t1930 pfet_05v0 ad=0.5368p pd=3.32u as=0.5368p ps=3.32u w=1.22u l=1u
X1639 VSS a_13280_11485# ana_div_chain\[2\]_dff_notouch_.Q VSS nfet_05v0 ad=0.3608p pd=2.52u as=0.2132p ps=1.34u w=0.82u l=0.6u
X1640 dac_div_chain\[1\]_inv_notouch_.I a_11144_12971# VSS VSS nfet_05v0 ad=0.2132p pd=1.34u as=0.3608p ps=2.52u w=0.82u l=0.6u
X1641 a_15356_17272# a_15268_17316# VSS VSS nfet_05v0 ad=0.3608p pd=2.52u as=0.3608p ps=2.52u w=0.82u l=1u
X1642 a_10204_3160# a_10116_3204# VSS VSS nfet_05v0 ad=0.3608p pd=2.52u as=0.3608p ps=2.52u w=0.82u l=1u
X1643 a_10971_13855# a_8996_13479# a_10336_13443# VDD.t1060 pfet_05v0 ad=0.1665p pd=1.285u as=0.1791p ps=1.355u w=0.36u l=0.5u
X1644 VDD.t1210 a_1468_12135# a_1380_12232# VDD.t1209 pfet_05v0 ad=0.5368p pd=3.32u as=0.5368p ps=3.32u w=1.22u l=1u
X1645 VDD.t1732 a_3708_7864# a_3620_7908# VDD.t311 pfet_05v0 ad=0.5368p pd=3.32u as=0.5368p ps=3.32u w=1.22u l=1u
X1646 a_11996_3160# a_11908_3204# VSS VSS nfet_05v0 ad=0.3608p pd=2.52u as=0.3608p ps=2.52u w=0.82u l=1u
X1647 a_15804_15704# a_15716_15748# VSS VSS nfet_05v0 ad=0.3608p pd=2.52u as=0.3608p ps=2.52u w=0.82u l=1u
X1648 a_15216_15055# a_14336_15368# a_14892_15055# VSS nfet_05v0 ad=43.2f pd=0.6u as=0.207p ps=1.51u w=0.36u l=0.6u
X1649 VDD.t1610 a_14572_8999# a_14484_9096# VDD.t1609 pfet_05v0 ad=0.5368p pd=3.32u as=0.5368p ps=3.32u w=1.22u l=1u
X1650 VDD.t568 a_15848_17776# ana_div_chain\[4\]_dff_notouch_.CLK VDD.t567 pfet_05v0 ad=0.4015p pd=1.92u as=0.5368p ps=3.32u w=1.22u l=0.5u
X1651 VDD.t1126 a_20620_4295# a_20532_4392# VDD.t1125 pfet_05v0 ad=0.5368p pd=3.32u as=0.5368p ps=3.32u w=1.22u l=1u
X1652 VDD.t1512 a_2812_12568# a_2724_12612# VDD.t1511 pfet_05v0 ad=0.5368p pd=3.32u as=0.5368p ps=3.32u w=1.22u l=1u
X1653 a_11212_7431# a_11124_7528# VSS VSS nfet_05v0 ad=0.3608p pd=2.52u as=0.3608p ps=2.52u w=0.82u l=1u
X1654 VDD.t310 a_4156_7431# a_4068_7528# VDD.t309 pfet_05v0 ad=0.5368p pd=3.32u as=0.5368p ps=3.32u w=1.22u l=1u
X1655 a_13676_16839# a_13588_16936# VSS VSS nfet_05v0 ad=0.3608p pd=2.52u as=0.3608p ps=2.52u w=0.82u l=1u
X1656 VDD.t1584 a_15398_14516# dvo[0].t2 VDD.t1583 pfet_05v0 ad=0.4941p pd=2.03u as=0.3782p ps=1.84u w=1.22u l=0.5u
X1657 VDD.t750 a_3260_4728# a_3172_4772# VDD.t334 pfet_05v0 ad=0.5368p pd=3.32u as=0.5368p ps=3.32u w=1.22u l=1u
X1658 a_8076_10567# a_7988_10664# VSS VSS nfet_05v0 ad=0.3608p pd=2.52u as=0.3608p ps=2.52u w=0.82u l=1u
X1659 a_18044_13703# a_17956_13800# VSS VSS nfet_05v0 ad=0.3608p pd=2.52u as=0.3608p ps=2.52u w=0.82u l=1u
X1660 VDD.t886 a_3260_1592# a_3172_1636# VDD.t6 pfet_05v0 ad=0.5368p pd=3.32u as=0.5368p ps=3.32u w=1.22u l=1u
X1661 a_16812_12135# a_16724_12232# VSS VSS nfet_05v0 ad=0.3608p pd=2.52u as=0.3608p ps=2.52u w=0.82u l=1u
X1662 a_15580_18407# a_15492_18504# VSS VSS nfet_05v0 ad=0.3608p pd=2.52u as=0.3608p ps=2.52u w=0.82u l=1u
X1663 a_17708_7431# a_17620_7528# VSS VSS nfet_05v0 ad=0.3608p pd=2.52u as=0.3608p ps=2.52u w=0.82u l=1u
X1664 a_18492_7864# a_18404_7908# VSS VSS nfet_05v0 ad=0.3608p pd=2.52u as=0.3608p ps=2.52u w=0.82u l=1u
X1665 VDD.t402 a_17260_10567# a_17172_10664# VDD.t401 pfet_05v0 ad=0.5368p pd=3.32u as=0.5368p ps=3.32u w=1.22u l=1u
X1666 a_18492_4728# a_18404_4772# VSS VSS nfet_05v0 ad=0.3608p pd=2.52u as=0.3608p ps=2.52u w=0.82u l=1u
X1667 a_12780_2727# a_12692_2824# VSS VSS nfet_05v0 ad=0.3608p pd=2.52u as=0.3608p ps=2.52u w=0.82u l=1u
X1668 VDD.t1826 a_9756_4728# a_9668_4772# VDD.t1825 pfet_05v0 ad=0.5368p pd=3.32u as=0.5368p ps=3.32u w=1.22u l=1u
X1669 VDD.t1626 a_18156_15704# a_18068_15748# VDD.t1625 pfet_05v0 ad=0.5368p pd=3.32u as=0.5368p ps=3.32u w=1.22u l=1u
X1670 VDD.t2078 a_7628_13703# a_7540_13800# VDD.t2077 pfet_05v0 ad=0.5368p pd=3.32u as=0.5368p ps=3.32u w=1.22u l=1u
X1671 VDD.t706 a_9756_1592# a_9668_1636# VDD.t705 pfet_05v0 ad=0.5368p pd=3.32u as=0.5368p ps=3.32u w=1.22u l=1u
X1672 a_9980_1159# a_9892_1256# VSS VSS nfet_05v0 ad=0.3608p pd=2.52u as=0.3608p ps=2.52u w=0.82u l=1u
X1673 a_5948_12568# a_5860_12612# VSS VSS nfet_05v0 ad=0.3608p pd=2.52u as=0.3608p ps=2.52u w=0.82u l=1u
X1674 a_9308_3160# a_9220_3204# VSS VSS nfet_05v0 ad=0.3608p pd=2.52u as=0.3608p ps=2.52u w=0.82u l=1u
X1675 a_13340_1592# a_13252_1636# VSS VSS nfet_05v0 ad=0.3608p pd=2.52u as=0.3608p ps=2.52u w=0.82u l=1u
X1676 VDD.t1844 a_7180_8999# a_7092_9096# VDD.t1843 pfet_05v0 ad=0.5368p pd=3.32u as=0.5368p ps=3.32u w=1.22u l=1u
X1677 a_13452_9432# a_13364_9476# VSS VSS nfet_05v0 ad=0.3608p pd=2.52u as=0.3608p ps=2.52u w=0.82u l=1u
X1678 VDD.t370 a_8972_5863# a_8884_5960# VDD.t369 pfet_05v0 ad=0.5368p pd=3.32u as=0.5368p ps=3.32u w=1.22u l=1u
X1679 a_10204_17272# a_10116_17316# VSS VSS nfet_05v0 ad=0.3608p pd=2.52u as=0.3608p ps=2.52u w=0.82u l=1u
X1680 a_5388_15271# a_5300_15368# VSS VSS nfet_05v0 ad=0.3608p pd=2.52u as=0.3608p ps=2.52u w=0.82u l=1u
X1681 VDD.t1261 a_8972_2727# a_8884_2824# VDD.t1260 pfet_05v0 ad=0.5368p pd=3.32u as=0.5368p ps=3.32u w=1.22u l=1u
X1682 VDD.t1470 a_3260_17272# a_3172_17316# VDD.t816 pfet_05v0 ad=0.5368p pd=3.32u as=0.5368p ps=3.32u w=1.22u l=1u
X1683 a_19836_1592# a_19748_1636# VSS VSS nfet_05v0 ad=0.3608p pd=2.52u as=0.3608p ps=2.52u w=0.82u l=1u
X1684 a_14880_11875# a_14432_11875# a_15292_12287# VDD.t1972 pfet_05v0 ad=0.1872p pd=1.4u as=43.2f ps=0.6u w=0.36u l=0.5u
X1685 a_5388_12135# a_5300_12232# VSS VSS nfet_05v0 ad=0.3608p pd=2.52u as=0.3608p ps=2.52u w=0.82u l=1u
X1686 a_15468_2727# a_15380_2824# VSS VSS nfet_05v0 ad=0.3608p pd=2.52u as=0.3608p ps=2.52u w=0.82u l=1u
X1687 VDD.t386 a_5388_7431# a_5300_7528# VDD.t385 pfet_05v0 ad=0.5368p pd=3.32u as=0.5368p ps=3.32u w=1.22u l=1u
X1688 VDD.t2058 a_18492_7864# a_18404_7908# VDD.t2057 pfet_05v0 ad=0.5368p pd=3.32u as=0.5368p ps=3.32u w=1.22u l=1u
X1689 a_5836_13703# a_5748_13800# VSS VSS nfet_05v0 ad=0.3608p pd=2.52u as=0.3608p ps=2.52u w=0.82u l=1u
X1690 VDD.t1268 a_15580_1159# a_15492_1256# VDD.t319 pfet_05v0 ad=0.5368p pd=3.32u as=0.5368p ps=3.32u w=1.22u l=1u
X1691 a_10316_4295# a_10228_4392# VSS VSS nfet_05v0 ad=0.3608p pd=2.52u as=0.3608p ps=2.52u w=0.82u l=1u
X1692 a_16700_9432# a_16612_9476# VSS VSS nfet_05v0 ad=0.3608p pd=2.52u as=0.3608p ps=2.52u w=0.82u l=1u
X1693 a_16028_1592# a_15940_1636# VSS VSS nfet_05v0 ad=0.3608p pd=2.52u as=0.3608p ps=2.52u w=0.82u l=1u
X1694 a_16700_6296# a_16612_6340# VSS VSS nfet_05v0 ad=0.3608p pd=2.52u as=0.3608p ps=2.52u w=0.82u l=1u
X1695 a_13564_13097# dac_div_chain\[1\]_inv_notouch_.ZN a_12640_12932# VSS nfet_05v0 ad=43.2f pd=0.6u as=0.207p ps=1.51u w=0.36u l=0.6u
X1696 a_17148_14136# a_17060_14180# VSS VSS nfet_05v0 ad=0.3608p pd=2.52u as=0.3608p ps=2.52u w=0.82u l=1u
X1697 VDD.t1074 a_5948_15704# a_5860_15748# VDD.t1073 pfet_05v0 ad=0.5368p pd=3.32u as=0.5368p ps=3.32u w=1.22u l=1u
X1698 a_17148_11000# a_17060_11044# VSS VSS nfet_05v0 ad=0.3608p pd=2.52u as=0.3608p ps=2.52u w=0.82u l=1u
X1699 VDD.t1025 a_17708_12135# a_17620_12232# VDD.t1024 pfet_05v0 ad=0.5368p pd=3.32u as=0.5368p ps=3.32u w=1.22u l=1u
X1700 VDD.t1767 a_10764_7431# a_10676_7528# VDD.t1766 pfet_05v0 ad=0.5368p pd=3.32u as=0.5368p ps=3.32u w=1.22u l=1u
X1701 a_19052_15704# a_18964_15748# VSS VSS nfet_05v0 ad=0.3608p pd=2.52u as=0.3608p ps=2.52u w=0.82u l=1u
X1702 VDD.t1575 a_1468_14136# a_1380_14180# VDD.t1458 pfet_05v0 ad=0.5368p pd=3.32u as=0.5368p ps=3.32u w=1.22u l=1u
X1703 VDD.t1676 a_1468_11000# a_1380_11044# VDD.t561 pfet_05v0 ad=0.5368p pd=3.32u as=0.5368p ps=3.32u w=1.22u l=1u
X1704 VDD.t673 a_20508_18407# a_20420_18504# VDD.t672 pfet_05v0 ad=0.5368p pd=3.32u as=0.5368p ps=3.32u w=1.22u l=1u
X1705 a_6732_4295# a_6644_4392# VSS VSS nfet_05v0 ad=0.3608p pd=2.52u as=0.3608p ps=2.52u w=0.82u l=1u
X1706 VDD.t450 a_21516_8999# a_21428_9096# VDD.t449 pfet_05v0 ad=0.5368p pd=3.32u as=0.5368p ps=3.32u w=1.22u l=1u
X1707 VDD.t181 a_7740_4728# a_7652_4772# VDD.t180 pfet_05v0 ad=0.5368p pd=3.32u as=0.5368p ps=3.32u w=1.22u l=1u
X1708 a_18492_13703# a_18404_13800# VSS VSS nfet_05v0 ad=0.3608p pd=2.52u as=0.3608p ps=2.52u w=0.82u l=1u
X1709 VDD.t724 a_7740_1592# a_7652_1636# VDD.t723 pfet_05v0 ad=0.5368p pd=3.32u as=0.5368p ps=3.32u w=1.22u l=1u
X1710 a_8076_2727# a_7988_2824# VSS VSS nfet_05v0 ad=0.3608p pd=2.52u as=0.3608p ps=2.52u w=0.82u l=1u
X1711 dac_div_chain\[3\]_inv_notouch_.I a_11264_13443# VSS VSS nfet_05v0 ad=0.2132p pd=1.34u as=0.3608p ps=2.52u w=0.82u l=0.6u
X1712 VDD.t872 a_2812_6296# a_2724_6340# VDD.t345 pfet_05v0 ad=0.5368p pd=3.32u as=0.5368p ps=3.32u w=1.22u l=1u
X1713 a_12780_10567# a_12692_10664# VSS VSS nfet_05v0 ad=0.3608p pd=2.52u as=0.3608p ps=2.52u w=0.82u l=1u
X1714 a_14684_6296# a_14596_6340# VSS VSS nfet_05v0 ad=0.3608p pd=2.52u as=0.3608p ps=2.52u w=0.82u l=1u
X1715 VDD.t1657 a_4156_9432# a_4068_9476# VDD.t778 pfet_05v0 ad=0.5368p pd=3.32u as=0.5368p ps=3.32u w=1.22u l=1u
X1716 VDD.t1550 a_2812_3160# a_2724_3204# VDD.t389 pfet_05v0 ad=0.5368p pd=3.32u as=0.5368p ps=3.32u w=1.22u l=1u
X1717 VDD.t1943 a_15020_4295# a_14932_4392# VDD.t1942 pfet_05v0 ad=0.5368p pd=3.32u as=0.5368p ps=3.32u w=1.22u l=1u
X1718 a_3260_15271# a_3172_15368# VSS VSS nfet_05v0 ad=0.3608p pd=2.52u as=0.3608p ps=2.52u w=0.82u l=1u
X1719 a_21068_8999# a_20980_9096# VSS VSS nfet_05v0 ad=0.3608p pd=2.52u as=0.3608p ps=2.52u w=0.82u l=1u
X1720 VDD.t224 a_19276_15271# a_19188_15368# VDD.t223 pfet_05v0 ad=0.5368p pd=3.32u as=0.5368p ps=3.32u w=1.22u l=1u
X1721 a_13676_7431# a_13588_7528# VSS VSS nfet_05v0 ad=0.3608p pd=2.52u as=0.3608p ps=2.52u w=0.82u l=1u
X1722 a_3260_12135# a_3172_12232# VSS VSS nfet_05v0 ad=0.3608p pd=2.52u as=0.3608p ps=2.52u w=0.82u l=1u
X1723 a_21068_5863# a_20980_5960# VSS VSS nfet_05v0 ad=0.3608p pd=2.52u as=0.3608p ps=2.52u w=0.82u l=1u
X1724 VDD.t1789 a_22076_6296# a_21988_6340# VDD.t1788 pfet_05v0 ad=0.5368p pd=3.32u as=0.5368p ps=3.32u w=1.22u l=1u
X1725 a_6396_17272# a_6308_17316# VSS VSS nfet_05v0 ad=0.3608p pd=2.52u as=0.3608p ps=2.52u w=0.82u l=1u
X1726 VDD.t142 a_13228_5863# a_13140_5960# VDD.t141 pfet_05v0 ad=0.5368p pd=3.32u as=0.5368p ps=3.32u w=1.22u l=1u
X1727 a_14768_13443# a_14280_13811# a_15200_13487# VSS nfet_05v0 ad=0.207p pd=1.51u as=43.2f ps=0.6u w=0.36u l=0.6u
X1728 VDD.t187 a_22076_3160# a_21988_3204# VDD.t186 pfet_05v0 ad=0.5368p pd=3.32u as=0.5368p ps=3.32u w=1.22u l=1u
X1729 VDD.t1818 a_13228_2727# a_13140_2824# VDD.t1817 pfet_05v0 ad=0.5368p pd=3.32u as=0.5368p ps=3.32u w=1.22u l=1u
X1730 a_15264_15011# a_14892_15055# VSS VSS nfet_05v0 ad=93.59999f pd=0.88u as=0.2637p ps=1.825u w=0.36u l=0.6u
X1731 VDD.t759 dac_div_chain\[4\]_inv_notouch_.I dac_div_chain\[4\]_dff_notouch_.D VDD.t758 pfet_05v0 ad=0.5368p pd=3.32u as=0.5368p ps=3.32u w=1.22u l=0.5u
X1732 a_12192_16233# a_11312_15819# a_11868_16233# VSS nfet_05v0 ad=43.2f pd=0.6u as=0.207p ps=1.51u w=0.36u l=0.6u
X1733 a_19948_2727# a_19860_2824# VSS VSS nfet_05v0 ad=0.3608p pd=2.52u as=0.3608p ps=2.52u w=0.82u l=1u
X1734 a_6844_15704# a_6756_15748# VSS VSS nfet_05v0 ad=0.3608p pd=2.52u as=0.3608p ps=2.52u w=0.82u l=1u
X1735 VDD.t344 a_13116_14136# a_13028_14180# VDD.t343 pfet_05v0 ad=0.5368p pd=3.32u as=0.5368p ps=3.32u w=1.22u l=1u
X1736 VDD.t67 a_9868_7431# a_9780_7528# VDD.t66 pfet_05v0 ad=0.5368p pd=3.32u as=0.5368p ps=3.32u w=1.22u l=1u
X1737 a_7292_9432# a_7204_9476# VSS VSS nfet_05v0 ad=0.3608p pd=2.52u as=0.3608p ps=2.52u w=0.82u l=1u
X1738 a_15020_11000# a_14932_11044# VSS VSS nfet_05v0 ad=0.3608p pd=2.52u as=0.3608p ps=2.52u w=0.82u l=1u
X1739 a_13788_1159# a_13700_1256# VSS VSS nfet_05v0 ad=0.3608p pd=2.52u as=0.3608p ps=2.52u w=0.82u l=1u
X1740 a_7292_6296# a_7204_6340# VSS VSS nfet_05v0 ad=0.3608p pd=2.52u as=0.3608p ps=2.52u w=0.82u l=1u
X1741 a_21068_15271# a_20980_15368# VSS VSS nfet_05v0 ad=0.3608p pd=2.52u as=0.3608p ps=2.52u w=0.82u l=1u
X1742 a_21068_12135# a_20980_12232# VSS VSS nfet_05v0 ad=0.3608p pd=2.52u as=0.3608p ps=2.52u w=0.82u l=1u
X1743 a_17596_14136# a_17508_14180# VSS VSS nfet_05v0 ad=0.3608p pd=2.52u as=0.3608p ps=2.52u w=0.82u l=1u
X1744 VDD.t1151 a_12038_17744# dvo[5].t3 VDD.t1150 pfet_05v0 ad=0.3782p pd=1.84u as=0.5368p ps=3.32u w=1.22u l=0.5u
X1745 a_6284_7431# a_6196_7528# VSS VSS nfet_05v0 ad=0.3608p pd=2.52u as=0.3608p ps=2.52u w=0.82u l=1u
X1746 a_17596_11000# a_17508_11044# VSS VSS nfet_05v0 ad=0.3608p pd=2.52u as=0.3608p ps=2.52u w=0.82u l=1u
X1747 a_3596_18407# a_3508_18504# VSS VSS nfet_05v0 ad=0.3608p pd=2.52u as=0.3608p ps=2.52u w=0.82u l=1u
X1748 VSS a_10788_17316# dvo[4].t1 VSS nfet_05v0 ad=0.2132p pd=1.34u as=0.2132p ps=1.34u w=0.82u l=0.6u
X1749 a_10652_3160# a_10564_3204# VSS VSS nfet_05v0 ad=0.3608p pd=2.52u as=0.3608p ps=2.52u w=0.82u l=1u
X1750 a_6732_16839# a_6644_16936# VSS VSS nfet_05v0 ad=0.3608p pd=2.52u as=0.3608p ps=2.52u w=0.82u l=1u
X1751 a_4156_4295# a_4068_4392# VSS VSS nfet_05v0 ad=0.3608p pd=2.52u as=0.3608p ps=2.52u w=0.82u l=1u
X1752 a_3708_16839# a_3620_16936# VSS VSS nfet_05v0 ad=0.3608p pd=2.52u as=0.3608p ps=2.52u w=0.82u l=1u
X1753 VDD.t1982 a_20956_18407# a_20868_18504# VDD.t1981 pfet_05v0 ad=0.5368p pd=3.32u as=0.5368p ps=3.32u w=1.22u l=1u
X1754 VDD.t1671 a_7180_12135# a_7092_12232# VDD.t1670 pfet_05v0 ad=0.5368p pd=3.32u as=0.5368p ps=3.32u w=1.22u l=1u
X1755 VDD.t148 a_13788_4728# a_13700_4772# VDD.t147 pfet_05v0 ad=0.5368p pd=3.32u as=0.5368p ps=3.32u w=1.22u l=1u
X1756 a_11660_7431# a_11572_7528# VSS VSS nfet_05v0 ad=0.3608p pd=2.52u as=0.3608p ps=2.52u w=0.82u l=1u
X1757 VDD.t662 a_4156_12135# a_4068_12232# VDD.t661 pfet_05v0 ad=0.5368p pd=3.32u as=0.5368p ps=3.32u w=1.22u l=1u
X1758 a_17484_15271# a_17396_15368# VSS VSS nfet_05v0 ad=0.3608p pd=2.52u as=0.3608p ps=2.52u w=0.82u l=1u
X1759 VDD.t288 a_13788_1592# a_13700_1636# VDD.t227 pfet_05v0 ad=0.5368p pd=3.32u as=0.5368p ps=3.32u w=1.22u l=1u
X1760 VDD.t1941 a_19500_4295# a_19412_4392# VDD.t1940 pfet_05v0 ad=0.5368p pd=3.32u as=0.5368p ps=3.32u w=1.22u l=1u
X1761 VDD.t1961 a_11212_5863# a_11124_5960# VDD.t1960 pfet_05v0 ad=0.5368p pd=3.32u as=0.5368p ps=3.32u w=1.22u l=1u
X1762 a_2812_14136# a_2724_14180# VSS VSS nfet_05v0 ad=0.3608p pd=2.52u as=0.3608p ps=2.52u w=0.82u l=1u
X1763 VDD.t722 a_11212_2727# a_11124_2824# VDD.t721 pfet_05v0 ad=0.5368p pd=3.32u as=0.5368p ps=3.32u w=1.22u l=1u
X1764 a_21628_9432# a_21540_9476# VSS VSS nfet_05v0 ad=0.3608p pd=2.52u as=0.3608p ps=2.52u w=0.82u l=1u
X1765 VSS a_11264_13443# dac_div_chain\[3\]_inv_notouch_.I VSS nfet_05v0 ad=0.3608p pd=2.52u as=0.2132p ps=1.34u w=0.82u l=0.6u
X1766 a_8008_11504# dvo[2].t6 VDD.t1965 VDD.t1964 pfet_05v0 ad=0.462p pd=2.98u as=0.4015p ps=1.92u w=1.05u l=0.5u
X1767 a_2812_11000# a_2724_11044# VSS VSS nfet_05v0 ad=0.3608p pd=2.52u as=0.3608p ps=2.52u w=0.82u l=1u
X1768 VSS a_10032_11875# wire12.I VSS nfet_05v0 ad=0.3608p pd=2.52u as=0.2132p ps=1.34u w=0.82u l=0.6u
X1769 a_21628_6296# a_21540_6340# VSS VSS nfet_05v0 ad=0.3608p pd=2.52u as=0.3608p ps=2.52u w=0.82u l=1u
X1770 VDD.t1229 a_5500_12568# a_5412_12612# VDD.t1228 pfet_05v0 ad=0.5368p pd=3.32u as=0.5368p ps=3.32u w=1.22u l=1u
X1771 VDD.t97 a_17708_5863# a_17620_5960# VDD.t96 pfet_05v0 ad=0.5368p pd=3.32u as=0.5368p ps=3.32u w=1.22u l=1u
X1772 a_3260_3160# a_3172_3204# VSS VSS nfet_05v0 ad=0.3608p pd=2.52u as=0.3608p ps=2.52u w=0.82u l=1u
X1773 VDD.t164 a_17708_2727# a_17620_2824# VDD.t163 pfet_05v0 ad=0.5368p pd=3.32u as=0.5368p ps=3.32u w=1.22u l=1u
X1774 VDD.t1416 a_9868_10567# a_9780_10664# VDD.t1415 pfet_05v0 ad=0.5368p pd=3.32u as=0.5368p ps=3.32u w=1.22u l=1u
X1775 VDD.t1606 a_18208_16579# ana_div_chain\[4\]_dff_notouch_.Q VDD.t1605 pfet_05v0 ad=0.854p pd=3.84u as=0.3172p ps=1.74u w=1.22u l=0.5u
X1776 a_19500_12135# a_19412_12232# VSS VSS nfet_05v0 ad=0.3608p pd=2.52u as=0.3608p ps=2.52u w=0.82u l=1u
X1777 VDD.t1286 dac_div_chain\[2\]_load_slew15.Z a_7764_11911# VDD.t1285 pfet_05v0 ad=0.2249p pd=1.385u as=0.3806p ps=2.61u w=0.865u l=0.5u
X1778 a_17280_16579# a_16908_16623# VSS VSS nfet_05v0 ad=93.59999f pd=0.88u as=0.2637p ps=1.825u w=0.36u l=0.6u
X1779 a_8188_14136# a_8100_14180# VSS VSS nfet_05v0 ad=0.3608p pd=2.52u as=0.3608p ps=2.52u w=0.82u l=1u
X1780 a_15020_10567# a_14932_10664# VSS VSS nfet_05v0 ad=0.3608p pd=2.52u as=0.3608p ps=2.52u w=0.82u l=1u
X1781 a_20896_13053# a_20603_12729# VSS VSS nfet_05v0 ad=0.176p pd=1.68u as=0.142p ps=1.14u w=0.4u l=0.6u
X1782 VDD.t1218 a_1468_16839# a_1380_16936# VDD.t1217 pfet_05v0 ad=0.5368p pd=3.32u as=0.5368p ps=3.32u w=1.22u l=1u
X1783 a_9756_3160# a_9668_3204# VSS VSS nfet_05v0 ad=0.3608p pd=2.52u as=0.3608p ps=2.52u w=0.82u l=1u
X1784 VDD.t2050 a_17148_18407# a_17060_18504# VDD.t2049 pfet_05v0 ad=0.5368p pd=3.32u as=0.5368p ps=3.32u w=1.22u l=1u
X1785 a_22076_17272# a_21988_17316# VSS VSS nfet_05v0 ad=0.3608p pd=2.52u as=0.3608p ps=2.52u w=0.82u l=1u
X1786 a_14124_2727# a_14036_2824# VSS VSS nfet_05v0 ad=0.3608p pd=2.52u as=0.3608p ps=2.52u w=0.82u l=1u
X1787 a_5388_4295# a_5300_4392# VSS VSS nfet_05v0 ad=0.3608p pd=2.52u as=0.3608p ps=2.52u w=0.82u l=1u
X1788 a_8860_17272# a_8772_17316# VSS VSS nfet_05v0 ad=0.3608p pd=2.52u as=0.3608p ps=2.52u w=0.82u l=1u
X1789 a_17565_808# dac_vco_in.t0 VSS VSS nfet_05v0 ad=0.333p pd=2.57u as=93.59999f ps=0.88u w=0.36u l=0.6u
X1790 VDD.t2069 a_6396_4728# a_6308_4772# VDD.t2068 pfet_05v0 ad=0.5368p pd=3.32u as=0.5368p ps=3.32u w=1.22u l=1u
X1791 VSS a_12640_12932# a_12536_13097# VSS nfet_05v0 ad=0.2637p pd=1.825u as=93.59999f ps=0.88u w=0.36u l=0.6u
X1792 VDD.t586 a_10204_9432# a_10116_9476# VDD.t585 pfet_05v0 ad=0.5368p pd=3.32u as=0.5368p ps=3.32u w=1.22u l=1u
X1793 VDD.t318 a_6396_1592# a_6308_1636# VDD.t317 pfet_05v0 ad=0.5368p pd=3.32u as=0.5368p ps=3.32u w=1.22u l=1u
X1794 VDD.t1694 a_4940_15271# a_4852_15368# VDD.t1693 pfet_05v0 ad=0.5368p pd=3.32u as=0.5368p ps=3.32u w=1.22u l=1u
X1795 a_10032_11875# a_9739_12287# VSS VSS nfet_05v0 ad=0.176p pd=1.68u as=0.142p ps=1.14u w=0.4u l=0.6u
X1796 VSS a_14320_13443# a_14280_13811# VSS nfet_05v0 ad=0.1053p pd=0.925u as=0.1782p ps=1.69u w=0.405u l=0.6u
X1797 a_18828_1159# a_18740_1256# VSS VSS nfet_05v0 ad=0.3608p pd=2.52u as=0.3608p ps=2.52u w=0.82u l=1u
X1798 VDD.t118 a_1468_6296# a_1380_6340# VDD.t20 pfet_05v0 ad=0.5368p pd=3.32u as=0.5368p ps=3.32u w=1.22u l=1u
X1799 a_15312_11919# a_14776_11919# VSS VSS nfet_05v0 ad=43.2f pd=0.6u as=0.2637p ps=1.825u w=0.36u l=0.6u
X1800 VDD.t966 a_1916_15271# a_1828_15368# VDD.t965 pfet_05v0 ad=0.5368p pd=3.32u as=0.5368p ps=3.32u w=1.22u l=1u
X1801 VDD.t631 a_1468_3160# a_1380_3204# VDD.t246 pfet_05v0 ad=0.5368p pd=3.32u as=0.5368p ps=3.32u w=1.22u l=1u
X1802 a_8076_15271# a_7988_15368# VSS VSS nfet_05v0 ad=0.3608p pd=2.52u as=0.3608p ps=2.52u w=0.82u l=1u
X1803 VDD.t1488 a_13168_16189# a_13160_15865# VDD.t1487 pfet_05v0 ad=0.23p pd=1.54u as=50.4f ps=0.64u w=0.36u l=0.5u
X1804 a_10764_4295# a_10676_4392# VSS VSS nfet_05v0 ad=0.3608p pd=2.52u as=0.3608p ps=2.52u w=0.82u l=1u
X1805 a_3708_8999# a_3620_9096# VSS VSS nfet_05v0 ad=0.3608p pd=2.52u as=0.3608p ps=2.52u w=0.82u l=1u
X1806 a_3708_5863# a_3620_5960# VSS VSS nfet_05v0 ad=0.3608p pd=2.52u as=0.3608p ps=2.52u w=0.82u l=1u
X1807 a_12240_16189# a_11868_16233# VSS VSS nfet_05v0 ad=93.59999f pd=0.88u as=0.2637p ps=1.825u w=0.36u l=0.6u
X1808 a_8524_13703# a_8436_13800# VSS VSS nfet_05v0 ad=0.3608p pd=2.52u as=0.3608p ps=2.52u w=0.82u l=1u
X1809 VDD.t865 a_15916_7431# a_15828_7528# VDD.t864 pfet_05v0 ad=0.5368p pd=3.32u as=0.5368p ps=3.32u w=1.22u l=1u
X1810 VDD.t214 a_7964_18407# a_7876_18504# VDD.t213 pfet_05v0 ad=0.5368p pd=3.32u as=0.5368p ps=3.32u w=1.22u l=1u
X1811 a_2812_10567# a_2724_10664# VSS VSS nfet_05v0 ad=0.3608p pd=2.52u as=0.3608p ps=2.52u w=0.82u l=1u
X1812 VSS a_8902_11472# dvo[3].t0 VSS nfet_05v0 ad=0.2132p pd=1.34u as=0.3608p ps=2.52u w=0.82u l=0.6u
X1813 VDD.t1781 a_1916_4295# a_1828_4392# VDD.t866 pfet_05v0 ad=0.5368p pd=3.32u as=0.5368p ps=3.32u w=1.22u l=1u
X1814 a_17260_8999# a_17172_9096# VSS VSS nfet_05v0 ad=0.3608p pd=2.52u as=0.3608p ps=2.52u w=0.82u l=1u
X1815 a_11256_16533# dvo[4].t6 VSS VSS nfet_05v0 ad=0.1584p pd=1.6u as=0.153p ps=1.195u w=0.36u l=0.6u
X1816 a_13340_6296# a_13252_6340# VSS VSS nfet_05v0 ad=0.3608p pd=2.52u as=0.3608p ps=2.52u w=0.82u l=1u
X1817 VDD.t448 a_21964_8999# a_21876_9096# VDD.t447 pfet_05v0 ad=0.5368p pd=3.32u as=0.5368p ps=3.32u w=1.22u l=1u
X1818 VDD.t329 a_1916_1159# a_1828_1256# VDD.t0 pfet_05v0 ad=0.5368p pd=3.32u as=0.5368p ps=3.32u w=1.22u l=1u
X1819 a_17260_5863# a_17172_5960# VSS VSS nfet_05v0 ad=0.3608p pd=2.52u as=0.3608p ps=2.52u w=0.82u l=1u
X1820 a_14892_15055# ana_div_chain\[3\]_inv_notouch_.ZN a_14724_15055# VSS nfet_05v0 ad=0.207p pd=1.51u as=43.2f ps=0.6u w=0.36u l=0.6u
X1821 VDD.t1477 a_4156_14136# a_4068_14180# VDD.t595 pfet_05v0 ad=0.5368p pd=3.32u as=0.5368p ps=3.32u w=1.22u l=1u
X1822 a_1468_12568# a_1380_12612# VSS VSS nfet_05v0 ad=0.3608p pd=2.52u as=0.3608p ps=2.52u w=0.82u l=1u
X1823 a_19836_9432# a_19748_9476# VSS VSS nfet_05v0 ad=0.3608p pd=2.52u as=0.3608p ps=2.52u w=0.82u l=1u
X1824 VDD.t754 a_12108_7431# a_12020_7528# VDD.t753 pfet_05v0 ad=0.5368p pd=3.32u as=0.5368p ps=3.32u w=1.22u l=1u
X1825 VDD.t1430 a_9308_9432# a_9220_9476# VDD.t1429 pfet_05v0 ad=0.5368p pd=3.32u as=0.5368p ps=3.32u w=1.22u l=1u
X1826 a_7740_3160# a_7652_3204# VSS VSS nfet_05v0 ad=0.3608p pd=2.52u as=0.3608p ps=2.52u w=0.82u l=1u
X1827 a_19836_6296# a_19748_6340# VSS VSS nfet_05v0 ad=0.3608p pd=2.52u as=0.3608p ps=2.52u w=0.82u l=1u
X1828 VDD.t2065 a_4156_11000# a_4068_11044# VDD.t1407 pfet_05v0 ad=0.5368p pd=3.32u as=0.5368p ps=3.32u w=1.22u l=1u
X1829 a_2812_7864# a_2724_7908# VSS VSS nfet_05v0 ad=0.3608p pd=2.52u as=0.3608p ps=2.52u w=0.82u l=1u
X1830 VDD.t442 a_13280_11485# a_13272_11161# VDD.t441 pfet_05v0 ad=0.23p pd=1.54u as=50.4f ps=0.64u w=0.36u l=0.5u
X1831 a_2812_4728# a_2724_4772# VSS VSS nfet_05v0 ad=0.3608p pd=2.52u as=0.3608p ps=2.52u w=0.82u l=1u
X1832 a_8902_11472# wire12.I VSS VSS nfet_05v0 ad=0.3608p pd=2.52u as=0.2911p ps=1.53u w=0.82u l=0.6u
X1833 a_15848_17776# avo[4].t6 VDD.t1850 VDD.t1849 pfet_05v0 ad=0.462p pd=2.98u as=0.4015p ps=1.92u w=1.05u l=0.5u
X1834 a_3260_1159# a_3172_1256# VSS VSS nfet_05v0 ad=0.3608p pd=2.52u as=0.3608p ps=2.52u w=0.82u l=1u
X1835 VDD.t1775 a_13676_5863# a_13588_5960# VDD.t1774 pfet_05v0 ad=0.5368p pd=3.32u as=0.5368p ps=3.32u w=1.22u l=1u
X1836 a_16028_6296# a_15940_6340# VSS VSS nfet_05v0 ad=0.3608p pd=2.52u as=0.3608p ps=2.52u w=0.82u l=1u
X1837 a_17280_16579# a_16908_16623# VDD.t1070 VDD.t1069 pfet_05v0 ad=0.1791p pd=1.355u as=0.1044p ps=0.94u w=0.36u l=0.5u
X1838 a_18604_2727# a_18516_2824# VSS VSS nfet_05v0 ad=0.3608p pd=2.52u as=0.3608p ps=2.52u w=0.82u l=1u
X1839 a_9868_4295# a_9780_4392# VSS VSS nfet_05v0 ad=0.3608p pd=2.52u as=0.3608p ps=2.52u w=0.82u l=1u
X1840 VDD.t895 a_13676_2727# a_13588_2824# VDD.t894 pfet_05v0 ad=0.5368p pd=3.32u as=0.5368p ps=3.32u w=1.22u l=1u
X1841 VDD.t1828 a_8524_7431# a_8436_7528# VDD.t1827 pfet_05v0 ad=0.5368p pd=3.32u as=0.5368p ps=3.32u w=1.22u l=1u
X1842 a_22076_7864# a_21988_7908# VSS VSS nfet_05v0 ad=0.3608p pd=2.52u as=0.3608p ps=2.52u w=0.82u l=1u
X1843 a_20732_1592# a_20644_1636# VSS VSS nfet_05v0 ad=0.3608p pd=2.52u as=0.3608p ps=2.52u w=0.82u l=1u
X1844 a_22076_4728# a_21988_4772# VSS VSS nfet_05v0 ad=0.3608p pd=2.52u as=0.3608p ps=2.52u w=0.82u l=1u
X1845 VDD.t1747 a_5948_6296# a_5860_6340# VDD.t1746 pfet_05v0 ad=0.5368p pd=3.32u as=0.5368p ps=3.32u w=1.22u l=1u
X1846 VDD.t499 a_5948_3160# a_5860_3204# VDD.t498 pfet_05v0 ad=0.5368p pd=3.32u as=0.5368p ps=3.32u w=1.22u l=1u
X1847 VDD.t238 a_18156_4295# a_18068_4392# VDD.t237 pfet_05v0 ad=0.5368p pd=3.32u as=0.5368p ps=3.32u w=1.22u l=1u
X1848 VDD.t1715 a_1468_15704# a_1380_15748# VDD.t1714 pfet_05v0 ad=0.5368p pd=3.32u as=0.5368p ps=3.32u w=1.22u l=1u
X1849 VDD.t1426 a_20620_15271# a_20532_15368# VDD.t1425 pfet_05v0 ad=0.5368p pd=3.32u as=0.5368p ps=3.32u w=1.22u l=1u
X1850 a_12780_15271# a_12692_15368# VSS VSS nfet_05v0 ad=0.3608p pd=2.52u as=0.3608p ps=2.52u w=0.82u l=1u
X1851 VDD.t1461 a_1020_13703# a_932_13800# VDD.t1460 pfet_05v0 ad=0.5368p pd=3.32u as=0.5368p ps=3.32u w=1.22u l=1u
X1852 VDD.t1735 a_2812_7864# a_2724_7908# VDD.t1734 pfet_05v0 ad=0.5368p pd=3.32u as=0.5368p ps=3.32u w=1.22u l=1u
X1853 VDD.t1420 a_8792_10261# dac_div_chain\[2\]_load_slew11.Z VDD.t1419 pfet_05v0 ad=0.4015p pd=1.92u as=0.5368p ps=3.32u w=1.22u l=0.5u
X1854 VSS a_16192_15011# a_16144_15055# VSS nfet_05v0 ad=0.142p pd=1.14u as=43.2f ps=0.6u w=0.36u l=0.6u
X1855 VDD.t787 a_6284_5863# a_6196_5960# VDD.t786 pfet_05v0 ad=0.5368p pd=3.32u as=0.5368p ps=3.32u w=1.22u l=1u
X1856 a_17752_18101# avo[5].t7 VDD.t1846 VDD.t1845 pfet_05v0 ad=0.462p pd=2.98u as=0.4015p ps=1.92u w=1.05u l=0.5u
X1857 a_16611_808# a_16941_808# a_17061_852# VSS nfet_05v0 ad=0.3705p pd=2.77u as=43.8f ps=0.605u w=0.365u l=0.6u
X1858 VDD.t718 a_6284_2727# a_6196_2824# VDD.t717 pfet_05v0 ad=0.5368p pd=3.32u as=0.5368p ps=3.32u w=1.22u l=1u
X1859 VDD.t47 a_12444_4728# a_12356_4772# VDD.t46 pfet_05v0 ad=0.5368p pd=3.32u as=0.5368p ps=3.32u w=1.22u l=1u
X1860 VDD.t1596 a_8902_11472# dvo[3].t5 VDD.t1595 pfet_05v0 ad=0.4941p pd=2.03u as=0.3782p ps=1.84u w=1.22u l=0.5u
X1861 VDD.t1367 a_14280_13811# a_15636_13855# VDD.t1366 pfet_05v0 ad=0.4554p pd=3.25u as=54f ps=0.66u w=0.36u l=0.5u
X1862 a_17148_1592# a_17060_1636# VSS VSS nfet_05v0 ad=0.3608p pd=2.52u as=0.3608p ps=2.52u w=0.82u l=1u
X1863 VDD.t269 a_3260_7431# a_3172_7528# VDD.t268 pfet_05v0 ad=0.5368p pd=3.32u as=0.5368p ps=3.32u w=1.22u l=1u
X1864 a_13280_11485# a_12987_11161# VSS VSS nfet_05v0 ad=0.176p pd=1.68u as=0.142p ps=1.14u w=0.4u l=0.6u
X1865 VDD.t1801 a_12444_1592# a_12356_1636# VDD.t153 pfet_05v0 ad=0.5368p pd=3.32u as=0.5368p ps=3.32u w=1.22u l=1u
X1866 VDD.t348 a_22076_7864# a_21988_7908# VDD.t347 pfet_05v0 ad=0.5368p pd=3.32u as=0.5368p ps=3.32u w=1.22u l=1u
X1867 dvo[3].t1 a_8902_11472# VSS VSS nfet_05v0 ad=0.2132p pd=1.34u as=0.2132p ps=1.34u w=0.82u l=0.6u
X1868 a_9420_16839# a_9332_16936# VSS VSS nfet_05v0 ad=0.3608p pd=2.52u as=0.3608p ps=2.52u w=0.82u l=1u
X1869 a_16812_7431# a_16724_7528# VSS VSS nfet_05v0 ad=0.3608p pd=2.52u as=0.3608p ps=2.52u w=0.82u l=1u
X1870 avo[1].t1 a_20662_13352# VSS VSS nfet_05v0 ad=0.2132p pd=1.34u as=0.2132p ps=1.34u w=0.82u l=0.6u
X1871 a_14908_17272# a_14820_17316# VSS VSS nfet_05v0 ad=0.3608p pd=2.52u as=0.3608p ps=2.52u w=0.82u l=1u
X1872 VDD.t85 a_11660_5863# a_11572_5960# VDD.t84 pfet_05v0 ad=0.5368p pd=3.32u as=0.5368p ps=3.32u w=1.22u l=1u
X1873 VDD.t1867 a_12444_18407# a_12356_18504# VDD.t1866 pfet_05v0 ad=0.5368p pd=3.32u as=0.5368p ps=3.32u w=1.22u l=1u
X1874 VDD.t260 a_11660_2727# a_11572_2824# VDD.t259 pfet_05v0 ad=0.5368p pd=3.32u as=0.5368p ps=3.32u w=1.22u l=1u
X1875 VDD.t368 a_8860_4728# a_8772_4772# VDD.t367 pfet_05v0 ad=0.5368p pd=3.32u as=0.5368p ps=3.32u w=1.22u l=1u
X1876 a_13788_3160# a_13700_3204# VSS VSS nfet_05v0 ad=0.3608p pd=2.52u as=0.3608p ps=2.52u w=0.82u l=1u
X1877 VDD.t1259 a_8860_1592# a_8772_1636# VDD.t1258 pfet_05v0 ad=0.5368p pd=3.32u as=0.5368p ps=3.32u w=1.22u l=1u
X1878 VDD.t1614 a_16364_8999# a_16276_9096# VDD.t1613 pfet_05v0 ad=0.5368p pd=3.32u as=0.5368p ps=3.32u w=1.22u l=1u
X1879 a_2364_15704# a_2276_15748# VSS VSS nfet_05v0 ad=0.3608p pd=2.52u as=0.3608p ps=2.52u w=0.82u l=1u
X1880 VDD.t981 a_12108_9432# a_12020_9476# VDD.t587 pfet_05v0 ad=0.5368p pd=3.32u as=0.5368p ps=3.32u w=1.22u l=1u
X1881 a_5500_14136# a_5412_14180# VSS VSS nfet_05v0 ad=0.3608p pd=2.52u as=0.3608p ps=2.52u w=0.82u l=1u
X1882 a_5500_11000# a_5412_11044# VSS VSS nfet_05v0 ad=0.3608p pd=2.52u as=0.3608p ps=2.52u w=0.82u l=1u
X1883 VDD.t1240 a_5052_4728# a_4964_4772# VDD.t1239 pfet_05v0 ad=0.5368p pd=3.32u as=0.5368p ps=3.32u w=1.22u l=1u
X1884 VDD.t156 a_5052_1592# a_4964_1636# VDD.t155 pfet_05v0 ad=0.5368p pd=3.32u as=0.5368p ps=3.32u w=1.22u l=1u
X1885 avo[0].t0 a_20420_14180# VDD.t578 VDD.t577 pfet_05v0 ad=0.3782p pd=1.84u as=0.4941p ps=2.03u w=1.22u l=0.5u
X1886 a_7628_10567# a_7540_10664# VSS VSS nfet_05v0 ad=0.3608p pd=2.52u as=0.3608p ps=2.52u w=0.82u l=1u
X1887 a_18940_1592# a_18852_1636# VSS VSS nfet_05v0 ad=0.3608p pd=2.52u as=0.3608p ps=2.52u w=0.82u l=1u
X1888 a_14572_2727# a_14484_2824# VSS VSS nfet_05v0 ad=0.3608p pd=2.52u as=0.3608p ps=2.52u w=0.82u l=1u
X1889 a_9420_7431# a_9332_7528# VSS VSS nfet_05v0 ad=0.3608p pd=2.52u as=0.3608p ps=2.52u w=0.82u l=1u
X1890 VDD.t584 a_10652_9432# a_10564_9476# VDD.t583 pfet_05v0 ad=0.5368p pd=3.32u as=0.5368p ps=3.32u w=1.22u l=1u
X1891 VDD.t404 a_16812_10567# a_16724_10664# VDD.t403 pfet_05v0 ad=0.5368p pd=3.32u as=0.5368p ps=3.32u w=1.22u l=1u
X1892 VDD.t833 a_7180_16839# a_7092_16936# VDD.t832 pfet_05v0 ad=0.5368p pd=3.32u as=0.5368p ps=3.32u w=1.22u l=1u
X1893 VDD.t1147 a_4156_16839# a_4068_16936# VDD.t431 pfet_05v0 ad=0.5368p pd=3.32u as=0.5368p ps=3.32u w=1.22u l=1u
X1894 a_17915_16991# a_15940_16615# a_17280_16579# VDD.t989 pfet_05v0 ad=0.1665p pd=1.285u as=0.1791p ps=1.355u w=0.36u l=0.5u
X1895 VDD.t1628 a_17708_15704# a_17620_15748# VDD.t1627 pfet_05v0 ad=0.5368p pd=3.32u as=0.5368p ps=3.32u w=1.22u l=1u
X1896 VDD.t1282 wire12.I a_8996_13479# VDD.t1281 pfet_05v0 ad=0.2249p pd=1.385u as=0.3806p ps=2.61u w=0.865u l=0.5u
X1897 a_6396_3160# a_6308_3204# VSS VSS nfet_05v0 ad=0.3608p pd=2.52u as=0.3608p ps=2.52u w=0.82u l=1u
X1898 a_15132_1592# a_15044_1636# VSS VSS nfet_05v0 ad=0.3608p pd=2.52u as=0.3608p ps=2.52u w=0.82u l=1u
X1899 VSS a_11366_10216# avo[2].t2 VSS nfet_05v0 ad=0.2132p pd=1.34u as=0.3608p ps=2.52u w=0.82u l=0.6u
X1900 a_1468_7864# a_1380_7908# VSS VSS nfet_05v0 ad=0.3608p pd=2.52u as=0.3608p ps=2.52u w=0.82u l=1u
X1901 a_15244_9432# a_15156_9476# VSS VSS nfet_05v0 ad=0.3608p pd=2.52u as=0.3608p ps=2.52u w=0.82u l=1u
X1902 a_15398_14516# input2.Z VDD.t1580 VDD.t1579 pfet_05v0 ad=0.5368p pd=3.32u as=0.4941p ps=2.03u w=1.22u l=0.5u
X1903 a_15916_4295# a_15828_4392# VSS VSS nfet_05v0 ad=0.3608p pd=2.52u as=0.3608p ps=2.52u w=0.82u l=1u
X1904 a_1468_4728# a_1380_4772# VSS VSS nfet_05v0 ad=0.3608p pd=2.52u as=0.3608p ps=2.52u w=0.82u l=1u
X1905 VDD.t1176 a_13900_9432# a_13812_9476# VDD.t1175 pfet_05v0 ad=0.5368p pd=3.32u as=0.5368p ps=3.32u w=1.22u l=1u
X1906 VDD.t1552 a_1020_12568# a_932_12612# VDD.t1211 pfet_05v0 ad=0.5368p pd=3.32u as=0.5368p ps=3.32u w=1.22u l=1u
X1907 VDD.t1471 a_2812_17272# a_2724_17316# VDD.t818 pfet_05v0 ad=0.5368p pd=3.32u as=0.5368p ps=3.32u w=1.22u l=1u
X1908 VDD.t534 a_20620_8999# a_20532_9096# VDD.t533 pfet_05v0 ad=0.5368p pd=3.32u as=0.5368p ps=3.32u w=1.22u l=1u
X1909 dvo[5].t1 a_12038_17744# VSS VSS nfet_05v0 ad=0.2132p pd=1.34u as=0.2132p ps=1.34u w=0.82u l=0.6u
X1910 a_7180_2727# a_7092_2824# VSS VSS nfet_05v0 ad=0.3608p pd=2.52u as=0.3608p ps=2.52u w=0.82u l=1u
X1911 a_12108_4295# a_12020_4392# VSS VSS nfet_05v0 ad=0.3608p pd=2.52u as=0.3608p ps=2.52u w=0.82u l=1u
X1912 VDD.t1404 a_5388_10567# a_5300_10664# VDD.t1403 pfet_05v0 ad=0.5368p pd=3.32u as=0.5368p ps=3.32u w=1.22u l=1u
X1913 VDD.t1659 a_3260_9432# a_3172_9476# VDD.t1526 pfet_05v0 ad=0.5368p pd=3.32u as=0.5368p ps=3.32u w=1.22u l=1u
X1914 VDD.t1865 a_12892_18407# a_12804_18504# VDD.t1864 pfet_05v0 ad=0.5368p pd=3.32u as=0.5368p ps=3.32u w=1.22u l=1u
X1915 a_11366_10216# wire18.I VSS VSS nfet_05v0 ad=0.3608p pd=2.52u as=0.2911p ps=1.53u w=0.82u l=0.6u
X1916 VSS a_20896_13053# a_20848_13097# VSS nfet_05v0 ad=0.142p pd=1.14u as=43.2f ps=0.6u w=0.36u l=0.6u
X1917 VSS a_14768_13443# a_14664_13487# VSS nfet_05v0 ad=0.2637p pd=1.825u as=93.59999f ps=0.88u w=0.36u l=0.6u
X1918 VDD.t426 a_8188_17272# a_8100_17316# VDD.t425 pfet_05v0 ad=0.5368p pd=3.32u as=0.5368p ps=3.32u w=1.22u l=1u
X1919 a_14336_15368# a_13924_15047# VDD.t1984 VDD.t1983 pfet_05v0 ad=0.3806p pd=2.61u as=0.2249p ps=1.385u w=0.865u l=0.5u
X1920 a_12780_7431# a_12692_7528# VSS VSS nfet_05v0 ad=0.3608p pd=2.52u as=0.3608p ps=2.52u w=0.82u l=1u
X1921 VDD.t1428 a_9756_9432# a_9668_9476# VDD.t1427 pfet_05v0 ad=0.5368p pd=3.32u as=0.5368p ps=3.32u w=1.22u l=1u
X1922 VDD.t1859 a_20284_11000# a_20196_11044# VDD.t1858 pfet_05v0 ad=0.5368p pd=3.32u as=0.5368p ps=3.32u w=1.22u l=1u
X1923 VDD.t128 a_21180_6296# a_21092_6340# VDD.t127 pfet_05v0 ad=0.5368p pd=3.32u as=0.5368p ps=3.32u w=1.22u l=1u
X1924 VDD.t493 a_21180_3160# a_21092_3204# VDD.t492 pfet_05v0 ad=0.5368p pd=3.32u as=0.5368p ps=3.32u w=1.22u l=1u
X1925 a_8524_4295# a_8436_4392# VSS VSS nfet_05v0 ad=0.3608p pd=2.52u as=0.3608p ps=2.52u w=0.82u l=1u
X1926 VDD.t1741 a_1468_7864# a_1380_7908# VDD.t1740 pfet_05v0 ad=0.5368p pd=3.32u as=0.5368p ps=3.32u w=1.22u l=1u
X1927 a_18604_15704# a_18516_15748# VSS VSS nfet_05v0 ad=0.3608p pd=2.52u as=0.3608p ps=2.52u w=0.82u l=1u
X1928 a_4156_12568# a_4068_12612# VSS VSS nfet_05v0 ad=0.3608p pd=2.52u as=0.3608p ps=2.52u w=0.82u l=1u
X1929 a_12536_13097# a_12192_13053# a_11748_12568# VDD.t668 pfet_05v0 ad=0.1791p pd=1.355u as=0.1665p ps=1.285u w=0.36u l=0.5u
X1930 VDD.t1751 a_4604_6296# a_4516_6340# VDD.t1750 pfet_05v0 ad=0.5368p pd=3.32u as=0.5368p ps=3.32u w=1.22u l=1u
X1931 VDD.t1180 a_4604_3160# a_4516_3204# VDD.t1179 pfet_05v0 ad=0.5368p pd=3.32u as=0.5368p ps=3.32u w=1.22u l=1u
X1932 dvo[0].t3 a_15398_14516# VDD.t1582 VDD.t1581 pfet_05v0 ad=0.3782p pd=1.84u as=0.5368p ps=3.32u w=1.22u l=0.5u
X1933 VDD.t1963 a_8972_7431# a_8884_7528# VDD.t1962 pfet_05v0 ad=0.5368p pd=3.32u as=0.5368p ps=3.32u w=1.22u l=1u
X1934 a_14384_11919# a_13384_11784# VSS VSS nfet_05v0 ad=43.2f pd=0.6u as=0.142p ps=1.14u w=0.36u l=0.6u
X1935 a_18380_18407# a_18292_18504# VSS VSS nfet_05v0 ad=0.3608p pd=2.52u as=0.3608p ps=2.52u w=0.82u l=1u
X1936 a_21516_2727# a_21428_2824# VSS VSS nfet_05v0 ad=0.3608p pd=2.52u as=0.3608p ps=2.52u w=0.82u l=1u
X1937 a_15468_7431# a_15380_7528# VSS VSS nfet_05v0 ad=0.3608p pd=2.52u as=0.3608p ps=2.52u w=0.82u l=1u
X1938 a_2812_15271# a_2724_15368# VSS VSS nfet_05v0 ad=0.3608p pd=2.52u as=0.3608p ps=2.52u w=0.82u l=1u
X1939 VDD.t226 a_18828_15271# a_18740_15368# VDD.t225 pfet_05v0 ad=0.5368p pd=3.32u as=0.5368p ps=3.32u w=1.22u l=1u
X1940 a_2812_12135# a_2724_12232# VSS VSS nfet_05v0 ad=0.3608p pd=2.52u as=0.3608p ps=2.52u w=0.82u l=1u
X1941 a_5948_7864# a_5860_7908# VSS VSS nfet_05v0 ad=0.3608p pd=2.52u as=0.3608p ps=2.52u w=0.82u l=1u
X1942 a_5948_17272# a_5860_17316# VSS VSS nfet_05v0 ad=0.3608p pd=2.52u as=0.3608p ps=2.52u w=0.82u l=1u
X1943 a_5948_4728# a_5860_4772# VSS VSS nfet_05v0 ad=0.3608p pd=2.52u as=0.3608p ps=2.52u w=0.82u l=1u
X1944 VDD.t628 a_3260_10567# a_3172_10664# VDD.t627 pfet_05v0 ad=0.5368p pd=3.32u as=0.5368p ps=3.32u w=1.22u l=1u
X1945 a_16192_15011# a_15899_15423# VSS VSS nfet_05v0 ad=0.176p pd=1.68u as=0.142p ps=1.14u w=0.4u l=0.6u
X1946 VDD.t698 a_21068_4295# a_20980_4392# VDD.t697 pfet_05v0 ad=0.5368p pd=3.32u as=0.5368p ps=3.32u w=1.22u l=1u
X1947 a_3260_4295# a_3172_4392# VSS VSS nfet_05v0 ad=0.3608p pd=2.52u as=0.3608p ps=2.52u w=0.82u l=1u
X1948 VDD.t175 a_11100_4728# a_11012_4772# VDD.t174 pfet_05v0 ad=0.5368p pd=3.32u as=0.5368p ps=3.32u w=1.22u l=1u
X1949 VDD.t681 a_4156_15704# a_4068_15748# VDD.t680 pfet_05v0 ad=0.5368p pd=3.32u as=0.5368p ps=3.32u w=1.22u l=1u
X1950 a_14460_15704# a_14372_15748# VSS VSS nfet_05v0 ad=0.3608p pd=2.52u as=0.3608p ps=2.52u w=0.82u l=1u
X1951 VDD.t1822 a_11100_1592# a_11012_1636# VDD.t1821 pfet_05v0 ad=0.5368p pd=3.32u as=0.5368p ps=3.32u w=1.22u l=1u
X1952 VDD.t943 a_11366_10216# avo[2].t5 VDD.t942 pfet_05v0 ad=0.4941p pd=2.03u as=0.3782p ps=1.84u w=1.22u l=0.5u
X1953 a_7068_1159# a_6980_1256# VSS VSS nfet_05v0 ad=0.3608p pd=2.52u as=0.3608p ps=2.52u w=0.82u l=1u
X1954 ana_div_chain\[0\]_dff_notouch_.D ana_div_chain\[1\]_dff_notouch_.CLK VDD.t1570 VDD.t1569 pfet_05v0 ad=0.5368p pd=3.32u as=0.5368p ps=3.32u w=1.22u l=0.5u
X1955 VDD.t117 a_12892_4728# a_12804_4772# VDD.t116 pfet_05v0 ad=0.5368p pd=3.32u as=0.5368p ps=3.32u w=1.22u l=1u
X1956 VDD.t913 a_7740_9432# a_7652_9476# VDD.t912 pfet_05v0 ad=0.5368p pd=3.32u as=0.5368p ps=3.32u w=1.22u l=1u
X1957 a_17596_1592# a_17508_1636# VSS VSS nfet_05v0 ad=0.3608p pd=2.52u as=0.3608p ps=2.52u w=0.82u l=1u
X1958 VDD.t5 a_12892_1592# a_12804_1636# VDD.t4 pfet_05v0 ad=0.5368p pd=3.32u as=0.5368p ps=3.32u w=1.22u l=1u
X1959 a_8076_7431# a_7988_7528# VSS VSS nfet_05v0 ad=0.3608p pd=2.52u as=0.3608p ps=2.52u w=0.82u l=1u
X1960 a_20732_9432# a_20644_9476# VSS VSS nfet_05v0 ad=0.3608p pd=2.52u as=0.3608p ps=2.52u w=0.82u l=1u
X1961 VSS a_11144_12971# dac_div_chain\[1\]_inv_notouch_.I VSS nfet_05v0 ad=0.3608p pd=2.52u as=0.2132p ps=1.34u w=0.82u l=0.6u
X1962 a_12444_3160# a_12356_3204# VSS VSS nfet_05v0 ad=0.3608p pd=2.52u as=0.3608p ps=2.52u w=0.82u l=1u
X1963 a_20732_6296# a_20644_6340# VSS VSS nfet_05v0 ad=0.3608p pd=2.52u as=0.3608p ps=2.52u w=0.82u l=1u
X1964 VDD.t1608 a_15020_8999# a_14932_9096# VDD.t1607 pfet_05v0 ad=0.5368p pd=3.32u as=0.5368p ps=3.32u w=1.22u l=1u
X1965 VDD.t1682 a_21068_10567# a_20980_10664# VDD.t1681 pfet_05v0 ad=0.5368p pd=3.32u as=0.5368p ps=3.32u w=1.22u l=1u
X1966 VDD.t1500 a_6284_13703# a_6196_13800# VDD.t1499 pfet_05v0 ad=0.5368p pd=3.32u as=0.5368p ps=3.32u w=1.22u l=1u
X1967 a_16352_16936# a_15940_16615# VDD.t987 VDD.t986 pfet_05v0 ad=0.3806p pd=2.61u as=0.2249p ps=1.385u w=0.865u l=0.5u
X1968 VDD.t39 a_16812_5863# a_16724_5960# VDD.t38 pfet_05v0 ad=0.5368p pd=3.32u as=0.5368p ps=3.32u w=1.22u l=1u
X1969 VDD.t606 a_5948_7864# a_5860_7908# VDD.t605 pfet_05v0 ad=0.5368p pd=3.32u as=0.5368p ps=3.32u w=1.22u l=1u
X1970 VDD.t1392 a_13228_16839# a_13140_16936# VDD.t1391 pfet_05v0 ad=0.5368p pd=3.32u as=0.5368p ps=3.32u w=1.22u l=1u
X1971 VDD.t234 a_21740_13703# a_21652_13800# VDD.t233 pfet_05v0 ad=0.5368p pd=3.32u as=0.5368p ps=3.32u w=1.22u l=1u
X1972 VDD.t1992 a_16812_2727# a_16724_2824# VDD.t1991 pfet_05v0 ad=0.5368p pd=3.32u as=0.5368p ps=3.32u w=1.22u l=1u
X1973 VDD.t354 a_7292_14136# a_7204_14180# VDD.t353 pfet_05v0 ad=0.5368p pd=3.32u as=0.5368p ps=3.32u w=1.22u l=1u
X1974 a_21404_18407# a_21316_18504# VSS VSS nfet_05v0 ad=0.3608p pd=2.52u as=0.3608p ps=2.52u w=0.82u l=1u
X1975 VDD.t511 a_7292_11000# a_7204_11044# VDD.t510 pfet_05v0 ad=0.5368p pd=3.32u as=0.5368p ps=3.32u w=1.22u l=1u
X1976 VDD.t1954 a_13228_7431# a_13140_7528# VDD.t1953 pfet_05v0 ad=0.5368p pd=3.32u as=0.5368p ps=3.32u w=1.22u l=1u
X1977 ana_div_chain\[2\]_inv_notouch_.I a_10340_11575# VSS VSS nfet_05v0 ad=0.2178p pd=1.87u as=0.153p ps=1.195u w=0.495u l=0.6u
X1978 VDD.t1673 a_6732_12135# a_6644_12232# VDD.t1672 pfet_05v0 ad=0.5368p pd=3.32u as=0.5368p ps=3.32u w=1.22u l=1u
X1979 VDD.t650 a_15132_18407# a_15044_18504# VDD.t649 pfet_05v0 ad=0.5368p pd=3.32u as=0.5368p ps=3.32u w=1.22u l=1u
X1980 VDD.t980 a_12556_9432# a_12468_9476# VDD.t979 pfet_05v0 ad=0.5368p pd=3.32u as=0.5368p ps=3.32u w=1.22u l=1u
X1981 VDD.t1970 a_14392_12243# a_15748_12287# VDD.t1969 pfet_05v0 ad=0.4554p pd=3.25u as=54f ps=0.66u w=0.36u l=0.5u
X1982 a_8860_3160# a_8772_3204# VSS VSS nfet_05v0 ad=0.3608p pd=2.52u as=0.3608p ps=2.52u w=0.82u l=1u
X1983 VDD.t664 a_3708_12135# a_3620_12232# VDD.t663 pfet_05v0 ad=0.5368p pd=3.32u as=0.5368p ps=3.32u w=1.22u l=1u
X1984 VDD.t341 a_14728_14640# dac_div_chain\[1\]_dff_notouch_.CLK VDD.t340 pfet_05v0 ad=0.4015p pd=1.92u as=0.5368p ps=3.32u w=1.22u l=0.5u
X1985 a_5052_15704# a_4964_15748# VSS VSS nfet_05v0 ad=0.3608p pd=2.52u as=0.3608p ps=2.52u w=0.82u l=1u
X1986 a_19948_7431# a_19860_7528# VSS VSS nfet_05v0 ad=0.3608p pd=2.52u as=0.3608p ps=2.52u w=0.82u l=1u
X1987 a_17148_9432# a_17060_9476# VSS VSS nfet_05v0 ad=0.3608p pd=2.52u as=0.3608p ps=2.52u w=0.82u l=1u
X1988 a_17148_6296# a_17060_6340# VSS VSS nfet_05v0 ad=0.3608p pd=2.52u as=0.3608p ps=2.52u w=0.82u l=1u
X1989 a_5052_3160# a_4964_3204# VSS VSS nfet_05v0 ad=0.3608p pd=2.52u as=0.3608p ps=2.52u w=0.82u l=1u
X1990 VDD.t212 a_12640_12932# a_12536_13097# VDD.t211 pfet_05v0 ad=0.1044p pd=0.94u as=0.1791p ps=1.355u w=0.36u l=0.5u
X1991 a_1468_13703# a_1380_13800# VSS VSS nfet_05v0 ad=0.3608p pd=2.52u as=0.3608p ps=2.52u w=0.82u l=1u
X1992 VDD.t1244 a_9420_5863# a_9332_5960# VDD.t1243 pfet_05v0 ad=0.5368p pd=3.32u as=0.5368p ps=3.32u w=1.22u l=1u
X1993 VDD.t134 a_9420_2727# a_9332_2824# VDD.t133 pfet_05v0 ad=0.5368p pd=3.32u as=0.5368p ps=3.32u w=1.22u l=1u
X1994 a_15580_1592# a_15492_1636# VSS VSS nfet_05v0 ad=0.3608p pd=2.52u as=0.3608p ps=2.52u w=0.82u l=1u
X1995 a_2812_8999# a_2724_9096# VSS VSS nfet_05v0 ad=0.3608p pd=2.52u as=0.3608p ps=2.52u w=0.82u l=1u
X1996 VSS a_15264_15011# a_15216_15055# VSS nfet_05v0 ad=0.2637p pd=1.825u as=43.2f ps=0.6u w=0.36u l=0.6u
X1997 VDD.t640 a_19500_10567# a_19412_10664# VDD.t639 pfet_05v0 ad=0.5368p pd=3.32u as=0.5368p ps=3.32u w=1.22u l=1u
X1998 VDD.t734 a_19276_1159# a_19188_1256# VDD.t733 pfet_05v0 ad=0.5368p pd=3.32u as=0.5368p ps=3.32u w=1.22u l=1u
X1999 VDD.t1729 a_8188_4728# a_8100_4772# VDD.t1728 pfet_05v0 ad=0.5368p pd=3.32u as=0.5368p ps=3.32u w=1.22u l=1u
X2000 a_2812_5863# a_2724_5960# VSS VSS nfet_05v0 ad=0.3608p pd=2.52u as=0.3608p ps=2.52u w=0.82u l=1u
X2001 a_15692_9432# a_15604_9476# VSS VSS nfet_05v0 ad=0.3608p pd=2.52u as=0.3608p ps=2.52u w=0.82u l=1u
X2002 a_21628_17272# a_21540_17316# VSS VSS nfet_05v0 ad=0.3608p pd=2.52u as=0.3608p ps=2.52u w=0.82u l=1u
X2003 VDD.t892 a_8188_1592# a_8100_1636# VDD.t891 pfet_05v0 ad=0.5368p pd=3.32u as=0.5368p ps=3.32u w=1.22u l=1u
X2004 VDD.t1976 a_13988_12071# a_13384_11784# VDD.t1975 pfet_05v0 ad=0.23p pd=1.54u as=0.352p ps=2.48u w=0.8u l=0.5u
X2005 VSS a_16611_808# input2.Z VSS nfet_05v0 ad=0.28262p pd=1.87u as=0.3608p ps=2.52u w=0.82u l=0.6u
X2006 VSS ana_div_chain\[2\]_dff_notouch_.Q a_13924_15047# VSS nfet_05v0 ad=0.1053p pd=0.925u as=0.1782p ps=1.69u w=0.405u l=0.6u
X2007 a_10308_13855# a_8996_13479# a_9964_13487# VDD.t1059 pfet_05v0 ad=43.2f pd=0.6u as=0.1872p ps=1.4u w=0.36u l=0.5u
X2008 avo[1].t4 a_20662_13352# VDD.t1564 VDD.t1563 pfet_05v0 ad=0.3782p pd=1.84u as=0.3782p ps=1.84u w=1.22u l=0.5u
X2009 VDD.t538 a_19500_8999# a_19412_9096# VDD.t537 pfet_05v0 ad=0.5368p pd=3.32u as=0.5368p ps=3.32u w=1.22u l=1u
X2010 a_7628_15271# a_7540_15368# VSS VSS nfet_05v0 ad=0.3608p pd=2.52u as=0.3608p ps=2.52u w=0.82u l=1u
X2011 a_1020_14136# a_932_14180# VSS VSS nfet_05v0 ad=0.3608p pd=2.52u as=0.3608p ps=2.52u w=0.82u l=1u
X2012 VDD.t1916 a_11212_7431# a_11124_7528# VDD.t1915 pfet_05v0 ad=0.5368p pd=3.32u as=0.5368p ps=3.32u w=1.22u l=1u
X2013 a_18940_9432# a_18852_9476# VSS VSS nfet_05v0 ad=0.3608p pd=2.52u as=0.3608p ps=2.52u w=0.82u l=1u
X2014 a_18940_6296# a_18852_6340# VSS VSS nfet_05v0 ad=0.3608p pd=2.52u as=0.3608p ps=2.52u w=0.82u l=1u
X2015 a_1020_11000# a_932_11044# VSS VSS nfet_05v0 ad=0.3608p pd=2.52u as=0.3608p ps=2.52u w=0.82u l=1u
X2016 VDD.t976 a_5500_17272# a_5412_17316# VDD.t975 pfet_05v0 ad=0.5368p pd=3.32u as=0.5368p ps=3.32u w=1.22u l=1u
X2017 VDD.t1390 a_13676_16839# a_13588_16936# VDD.t1389 pfet_05v0 ad=0.5368p pd=3.32u as=0.5368p ps=3.32u w=1.22u l=1u
X2018 a_21852_18407# a_21764_18504# VSS VSS nfet_05v0 ad=0.3608p pd=2.52u as=0.3608p ps=2.52u w=0.82u l=1u
X2019 dvo[4].t0 a_10788_17316# VSS VSS nfet_05v0 ad=0.2132p pd=1.34u as=0.2911p ps=1.53u w=0.82u l=0.6u
X2020 VDD.t1379 a_9868_15271# a_9780_15368# VDD.t1378 pfet_05v0 ad=0.5368p pd=3.32u as=0.5368p ps=3.32u w=1.22u l=1u
X2021 VDD.t991 a_8076_10567# a_7988_10664# VDD.t990 pfet_05v0 ad=0.5368p pd=3.32u as=0.5368p ps=3.32u w=1.22u l=1u
X2022 VDD.t191 a_17708_7431# a_17620_7528# VDD.t190 pfet_05v0 ad=0.5368p pd=3.32u as=0.5368p ps=3.32u w=1.22u l=1u
X2023 VDD.t648 a_15580_18407# a_15492_18504# VDD.t647 pfet_05v0 ad=0.5368p pd=3.32u as=0.5368p ps=3.32u w=1.22u l=1u
X2024 a_2812_1159# a_2724_1256# VSS VSS nfet_05v0 ad=0.3608p pd=2.52u as=0.3608p ps=2.52u w=0.82u l=1u
X2025 VDD.t138 a_3708_4295# a_3620_4392# VDD.t137 pfet_05v0 ad=0.5368p pd=3.32u as=0.5368p ps=3.32u w=1.22u l=1u
X2026 VDD.t326 a_12780_5863# a_12692_5960# VDD.t325 pfet_05v0 ad=0.5368p pd=3.32u as=0.5368p ps=3.32u w=1.22u l=1u
X2027 a_15132_6296# a_15044_6340# VSS VSS nfet_05v0 ad=0.3608p pd=2.52u as=0.3608p ps=2.52u w=0.82u l=1u
X2028 a_19052_8999# a_18964_9096# VSS VSS nfet_05v0 ad=0.3608p pd=2.52u as=0.3608p ps=2.52u w=0.82u l=1u
X2029 a_8972_4295# a_8884_4392# VSS VSS nfet_05v0 ad=0.3608p pd=2.52u as=0.3608p ps=2.52u w=0.82u l=1u
X2030 a_19052_5863# a_18964_5960# VSS VSS nfet_05v0 ad=0.3608p pd=2.52u as=0.3608p ps=2.52u w=0.82u l=1u
X2031 VDD.t412 a_12780_2727# a_12692_2824# VDD.t411 pfet_05v0 ad=0.5368p pd=3.32u as=0.5368p ps=3.32u w=1.22u l=1u
X2032 VDD.t711 a_3708_1159# a_3620_1256# VDD.t242 pfet_05v0 ad=0.5368p pd=3.32u as=0.5368p ps=3.32u w=1.22u l=1u
X2033 a_12038_17744# dac_div_chain\[4\]_dff_notouch_.Q VDD.t1149 VDD.t1148 pfet_05v0 ad=0.5368p pd=3.32u as=0.4941p ps=2.03u w=1.22u l=0.5u
X2034 a_21180_7864# a_21092_7908# VSS VSS nfet_05v0 ad=0.3608p pd=2.52u as=0.3608p ps=2.52u w=0.82u l=1u
X2035 VDD.t1490 a_13168_16189# dac_div_chain\[4\]_dff_notouch_.Q VDD.t1489 pfet_05v0 ad=0.854p pd=3.84u as=0.3172p ps=1.74u w=1.22u l=0.5u
X2036 VDD.t2038 a_13272_13352# wire20.I VDD.t2037 pfet_05v0 ad=0.5368p pd=3.32u as=0.3172p ps=1.74u w=1.22u l=0.5u
X2037 a_21180_4728# a_21092_4772# VSS VSS nfet_05v0 ad=0.3608p pd=2.52u as=0.3608p ps=2.52u w=0.82u l=1u
X2038 a_14124_7431# a_14036_7528# VSS VSS nfet_05v0 ad=0.3608p pd=2.52u as=0.3608p ps=2.52u w=0.82u l=1u
X2039 VDD.t689 a_6396_9432# a_6308_9476# VDD.t688 pfet_05v0 ad=0.5368p pd=3.32u as=0.5368p ps=3.32u w=1.22u l=1u
X2040 VDD.t1184 a_17260_4295# a_17172_4392# VDD.t1183 pfet_05v0 ad=0.5368p pd=3.32u as=0.5368p ps=3.32u w=1.22u l=1u
X2041 VDD.t1478 a_3708_14136# a_3620_14180# VDD.t597 pfet_05v0 ad=0.5368p pd=3.32u as=0.5368p ps=3.32u w=1.22u l=1u
X2042 a_4604_7864# a_4516_7908# VSS VSS nfet_05v0 ad=0.3608p pd=2.52u as=0.3608p ps=2.52u w=0.82u l=1u
X2043 VDD.t1045 a_3708_11000# a_3620_11044# VDD.t625 pfet_05v0 ad=0.5368p pd=3.32u as=0.5368p ps=3.32u w=1.22u l=1u
X2044 VSS a_12192_13053# a_13564_13097# VSS nfet_05v0 ad=0.1584p pd=1.6u as=43.2f ps=0.6u w=0.36u l=0.6u
X2045 a_4604_4728# a_4516_4772# VSS VSS nfet_05v0 ad=0.3608p pd=2.52u as=0.3608p ps=2.52u w=0.82u l=1u
X2046 a_21964_2727# a_21876_2824# VSS VSS nfet_05v0 ad=0.3608p pd=2.52u as=0.3608p ps=2.52u w=0.82u l=1u
X2047 VDD.t308 a_15468_5863# a_15380_5960# VDD.t307 pfet_05v0 ad=0.5368p pd=3.32u as=0.5368p ps=3.32u w=1.22u l=1u
X2048 wire12.I a_10032_11875# VDD.t2088 VDD.t2087 pfet_05v0 ad=0.3172p pd=1.74u as=0.5368p ps=3.32u w=1.22u l=0.5u
X2049 VDD.t13 a_15468_2727# a_15380_2824# VDD.t12 pfet_05v0 ad=0.5368p pd=3.32u as=0.5368p ps=3.32u w=1.22u l=1u
X2050 VSS a_17280_16579# a_17232_16623# VSS nfet_05v0 ad=0.2637p pd=1.825u as=43.2f ps=0.6u w=0.36u l=0.6u
X2051 a_2364_16839# a_2276_16936# VSS VSS nfet_05v0 ad=0.3608p pd=2.52u as=0.3608p ps=2.52u w=0.82u l=1u
X2052 VSS dac_div_chain\[3\]_inv_notouch_.I a_10788_17316# VSS nfet_05v0 ad=0.2911p pd=1.53u as=0.3608p ps=2.52u w=0.82u l=0.6u
X2053 a_20603_12729# a_19040_12683# a_19968_13053# VSS nfet_05v0 ad=93.59999f pd=0.88u as=93.59999f ps=0.88u w=0.36u l=0.6u
X2054 VDD.t793 a_21180_7864# a_21092_7908# VDD.t792 pfet_05v0 ad=0.5368p pd=3.32u as=0.5368p ps=3.32u w=1.22u l=1u
X2055 a_1020_10567# a_932_10664# VSS VSS nfet_05v0 ad=0.3608p pd=2.52u as=0.3608p ps=2.52u w=0.82u l=1u
X2056 a_12536_13097# a_12152_12637# a_11748_12568# VSS nfet_05v0 ad=93.59999f pd=0.88u as=93.59999f ps=0.88u w=0.36u l=0.6u
X2057 a_6620_1159# a_6532_1256# VSS VSS nfet_05v0 ad=0.3608p pd=2.52u as=0.3608p ps=2.52u w=0.82u l=1u
X2058 a_11100_3160# a_11012_3204# VSS VSS nfet_05v0 ad=0.3608p pd=2.52u as=0.3608p ps=2.52u w=0.82u l=1u
X2059 VDD.t1165 a_1916_8999# a_1828_9096# VDD.t1164 pfet_05v0 ad=0.5368p pd=3.32u as=0.5368p ps=3.32u w=1.22u l=1u
X2060 VDD.t440 a_13280_11485# ana_div_chain\[2\]_dff_notouch_.Q VDD.t439 pfet_05v0 ad=0.854p pd=3.84u as=0.3172p ps=1.74u w=1.22u l=0.5u
X2061 a_19968_13053# a_19596_13097# VDD.t958 VDD.t957 pfet_05v0 ad=0.1791p pd=1.355u as=0.1044p ps=0.94u w=0.36u l=0.5u
X2062 VDD.t633 a_4604_7864# a_4516_7908# VDD.t632 pfet_05v0 ad=0.5368p pd=3.32u as=0.5368p ps=3.32u w=1.22u l=1u
X2063 dvo[4].t2 a_10788_17316# VSS VSS nfet_05v0 ad=0.3608p pd=2.52u as=0.2132p ps=1.34u w=0.82u l=0.6u
X2064 a_12892_3160# a_12804_3204# VSS VSS nfet_05v0 ad=0.3608p pd=2.52u as=0.3608p ps=2.52u w=0.82u l=1u
X2065 VDD.t752 a_8076_5863# a_7988_5960# VDD.t751 pfet_05v0 ad=0.5368p pd=3.32u as=0.5368p ps=3.32u w=1.22u l=1u
X2066 VDD.t740 a_8076_2727# a_7988_2824# VDD.t739 pfet_05v0 ad=0.5368p pd=3.32u as=0.5368p ps=3.32u w=1.22u l=1u
X2067 a_13228_4295# a_13140_4392# VSS VSS nfet_05v0 ad=0.3608p pd=2.52u as=0.3608p ps=2.52u w=0.82u l=1u
X2068 VDD.t81 a_14236_4728# a_14148_4772# VDD.t80 pfet_05v0 ad=0.5368p pd=3.32u as=0.5368p ps=3.32u w=1.22u l=1u
X2069 VDD.t152 a_14236_1592# a_14148_1636# VDD.t151 pfet_05v0 ad=0.5368p pd=3.32u as=0.5368p ps=3.32u w=1.22u l=1u
X2070 VDD.t1450 a_12780_10567# a_12692_10664# VDD.t1449 pfet_05v0 ad=0.5368p pd=3.32u as=0.5368p ps=3.32u w=1.22u l=1u
X2071 VSS a_12240_16189# a_12192_16233# VSS nfet_05v0 ad=0.2637p pd=1.825u as=43.2f ps=0.6u w=0.36u l=0.6u
X2072 a_12108_15271# a_12020_15368# VSS VSS nfet_05v0 ad=0.3608p pd=2.52u as=0.3608p ps=2.52u w=0.82u l=1u
X2073 a_1468_8999# a_1380_9096# VSS VSS nfet_05v0 ad=0.3608p pd=2.52u as=0.3608p ps=2.52u w=0.82u l=1u
X2074 a_1468_5863# a_1380_5960# VSS VSS nfet_05v0 ad=0.3608p pd=2.52u as=0.3608p ps=2.52u w=0.82u l=1u
X2075 VDD.t1592 a_8902_11472# dvo[3].t3 VDD.t1591 pfet_05v0 ad=0.3782p pd=1.84u as=0.5368p ps=3.32u w=1.22u l=0.5u
X2076 a_19836_14136# a_19748_14180# VSS VSS nfet_05v0 ad=0.3608p pd=2.52u as=0.3608p ps=2.52u w=0.82u l=1u
X2077 a_19836_11000# a_19748_11044# VSS VSS nfet_05v0 ad=0.3608p pd=2.52u as=0.3608p ps=2.52u w=0.82u l=1u
X2078 a_18604_7431# a_18516_7528# VSS VSS nfet_05v0 ad=0.3608p pd=2.52u as=0.3608p ps=2.52u w=0.82u l=1u
X2079 VDD.t1925 a_13676_7431# a_13588_7528# VDD.t1924 pfet_05v0 ad=0.5368p pd=3.32u as=0.5368p ps=3.32u w=1.22u l=1u
X2080 a_1020_1159# a_932_1256# VSS VSS nfet_05v0 ad=0.3608p pd=2.52u as=0.3608p ps=2.52u w=0.82u l=1u
X2081 a_1468_17272# a_1380_17316# VSS VSS nfet_05v0 ad=0.3608p pd=2.52u as=0.3608p ps=2.52u w=0.82u l=1u
X2082 a_7292_12568# a_7204_12612# VSS VSS nfet_05v0 ad=0.3608p pd=2.52u as=0.3608p ps=2.52u w=0.82u l=1u
X2083 VDD.t1688 a_18156_8999# a_18068_9096# VDD.t1687 pfet_05v0 ad=0.5368p pd=3.32u as=0.5368p ps=3.32u w=1.22u l=1u
X2084 a_17596_9432# a_17508_9476# VSS VSS nfet_05v0 ad=0.3608p pd=2.52u as=0.3608p ps=2.52u w=0.82u l=1u
X2085 VDD.t1721 a_19948_5863# a_19860_5960# VDD.t1720 pfet_05v0 ad=0.5368p pd=3.32u as=0.5368p ps=3.32u w=1.22u l=1u
X2086 a_19724_15271# a_19636_15368# VSS VSS nfet_05v0 ad=0.3608p pd=2.52u as=0.3608p ps=2.52u w=0.82u l=1u
X2087 a_17596_6296# a_17508_6340# VSS VSS nfet_05v0 ad=0.3608p pd=2.52u as=0.3608p ps=2.52u w=0.82u l=1u
X2088 a_8902_11472# wire12.I VDD.t1284 VDD.t1283 pfet_05v0 ad=0.5368p pd=3.32u as=0.4941p ps=2.03u w=1.22u l=0.5u
X2089 a_1916_15704# a_1828_15748# VSS VSS nfet_05v0 ad=0.3608p pd=2.52u as=0.3608p ps=2.52u w=0.82u l=1u
X2090 VDD.t179 a_19948_2727# a_19860_2824# VDD.t178 pfet_05v0 ad=0.5368p pd=3.32u as=0.5368p ps=3.32u w=1.22u l=1u
X2091 a_7180_13703# a_7092_13800# VSS VSS nfet_05v0 ad=0.3608p pd=2.52u as=0.3608p ps=2.52u w=0.82u l=1u
X2092 a_4156_13703# a_4068_13800# VSS VSS nfet_05v0 ad=0.3608p pd=2.52u as=0.3608p ps=2.52u w=0.82u l=1u
X2093 a_16364_2727# a_16276_2824# VSS VSS nfet_05v0 ad=0.3608p pd=2.52u as=0.3608p ps=2.52u w=0.82u l=1u
X2094 a_12640_12932# a_12192_13053# a_13052_12729# VDD.t669 pfet_05v0 ad=0.1872p pd=1.4u as=43.2f ps=0.6u w=0.36u l=0.5u
X2095 a_12668_14136# a_12580_14180# VSS VSS nfet_05v0 ad=0.3608p pd=2.52u as=0.3608p ps=2.52u w=0.82u l=1u
X2096 VSS a_19768_13397# ana_div_chain\[1\]_dff_notouch_.CLK VSS nfet_05v0 ad=0.153p pd=1.195u as=0.2178p ps=1.87u w=0.495u l=0.6u
X2097 VDD.t197 a_6284_7431# a_6196_7528# VDD.t196 pfet_05v0 ad=0.5368p pd=3.32u as=0.5368p ps=3.32u w=1.22u l=1u
X2098 ana_div_chain\[0\]_dff_notouch_.Q a_20896_13053# VSS VSS nfet_05v0 ad=0.2132p pd=1.34u as=0.3608p ps=2.52u w=0.82u l=0.6u
X2099 VDD.t1656 a_3596_18407# a_3508_18504# VDD.t1655 pfet_05v0 ad=0.5368p pd=3.32u as=0.5368p ps=3.32u w=1.22u l=1u
X2100 VDD.t1064 a_19052_12135# a_18964_12232# VDD.t1063 pfet_05v0 ad=0.5368p pd=3.32u as=0.5368p ps=3.32u w=1.22u l=1u
X2101 VDD.t1356 a_7292_15704# a_7204_15748# VDD.t1355 pfet_05v0 ad=0.5368p pd=3.32u as=0.5368p ps=3.32u w=1.22u l=1u
X2102 a_11212_4295# a_11124_4392# VSS VSS nfet_05v0 ad=0.3608p pd=2.52u as=0.3608p ps=2.52u w=0.82u l=1u
X2103 VDD.t552 a_6732_16839# a_6644_16936# VDD.t551 pfet_05v0 ad=0.5368p pd=3.32u as=0.5368p ps=3.32u w=1.22u l=1u
X2104 a_8188_3160# a_8100_3204# VSS VSS nfet_05v0 ad=0.3608p pd=2.52u as=0.3608p ps=2.52u w=0.82u l=1u
X2105 VDD.t815 a_3708_16839# a_3620_16936# VDD.t814 pfet_05v0 ad=0.5368p pd=3.32u as=0.5368p ps=3.32u w=1.22u l=1u
X2106 a_11312_15819# a_10900_16232# VDD.t1052 VDD.t1051 pfet_05v0 ad=0.3806p pd=2.61u as=0.2249p ps=1.385u w=0.865u l=0.5u
X2107 a_13116_17272# a_13028_17316# VSS VSS nfet_05v0 ad=0.3608p pd=2.52u as=0.3608p ps=2.52u w=0.82u l=1u
X2108 a_1916_1592# a_1828_1636# VSS VSS nfet_05v0 ad=0.3608p pd=2.52u as=0.3608p ps=2.52u w=0.82u l=1u
X2109 a_17708_4295# a_17620_4392# VSS VSS nfet_05v0 ad=0.3608p pd=2.52u as=0.3608p ps=2.52u w=0.82u l=1u
X2110 VDD.t1235 a_11660_7431# a_11572_7528# VDD.t1234 pfet_05v0 ad=0.5368p pd=3.32u as=0.5368p ps=3.32u w=1.22u l=1u
X2111 VDD.t1432 a_8860_9432# a_8772_9476# VDD.t1431 pfet_05v0 ad=0.5368p pd=3.32u as=0.5368p ps=3.32u w=1.22u l=1u
X2112 a_9308_15704# a_9220_15748# VSS VSS nfet_05v0 ad=0.3608p pd=2.52u as=0.3608p ps=2.52u w=0.82u l=1u
X2113 a_10428_1159# a_10340_1256# VSS VSS nfet_05v0 ad=0.3608p pd=2.52u as=0.3608p ps=2.52u w=0.82u l=1u
X2114 a_12875_15865# a_11312_15819# a_12240_16189# VSS nfet_05v0 ad=93.59999f pd=0.88u as=93.59999f ps=0.88u w=0.36u l=0.6u
X2115 a_20603_12729# a_18628_13096# a_19968_13053# VDD.t532 pfet_05v0 ad=0.1665p pd=1.285u as=0.1791p ps=1.355u w=0.36u l=0.5u
X2116 VSS a_20662_13352# avo[1].t2 VSS nfet_05v0 ad=0.2911p pd=1.53u as=0.2132p ps=1.34u w=0.82u l=0.6u
X2117 VDD.t1508 a_11144_12971# dac_div_chain\[1\]_inv_notouch_.I VDD.t1507 pfet_05v0 ad=0.5368p pd=3.32u as=0.3172p ps=1.74u w=1.22u l=0.5u
X2118 dvo[3].t4 a_8902_11472# VDD.t1594 VDD.t1593 pfet_05v0 ad=0.3782p pd=1.84u as=0.3782p ps=1.84u w=1.22u l=0.5u
X2119 VDD.t1558 a_5052_9432# a_4964_9476# VDD.t1557 pfet_05v0 ad=0.5368p pd=3.32u as=0.5368p ps=3.32u w=1.22u l=1u
X2120 a_15580_6296# a_15492_6340# VSS VSS nfet_05v0 ad=0.3608p pd=2.52u as=0.3608p ps=2.52u w=0.82u l=1u
X2121 VDD.t509 a_8008_11504# dac_div_chain\[2\]_load_slew15.Z VDD.t508 pfet_05v0 ad=0.4015p pd=1.92u as=0.5368p ps=3.32u w=1.22u l=0.5u
X2122 a_14880_11875# a_14392_12243# a_15312_11919# VSS nfet_05v0 ad=0.207p pd=1.51u as=43.2f ps=0.6u w=0.36u l=0.6u
X2123 a_13340_18407# a_13252_18504# VSS VSS nfet_05v0 ad=0.3608p pd=2.52u as=0.3608p ps=2.52u w=0.82u l=1u
X2124 a_14572_7431# a_14484_7528# VSS VSS nfet_05v0 ad=0.3608p pd=2.52u as=0.3608p ps=2.52u w=0.82u l=1u
X2125 a_19768_13397# avo[1].t6 VSS VSS nfet_05v0 ad=0.1584p pd=1.6u as=0.153p ps=1.195u w=0.36u l=0.6u
X2126 a_20620_2727# a_20532_2824# VSS VSS nfet_05v0 ad=0.3608p pd=2.52u as=0.3608p ps=2.52u w=0.82u l=1u
X2127 VDD.t1003 a_15020_10567# a_14932_10664# VDD.t1002 pfet_05v0 ad=0.5368p pd=3.32u as=0.5368p ps=3.32u w=1.22u l=1u
X2128 VDD.t95 a_14124_5863# a_14036_5960# VDD.t94 pfet_05v0 ad=0.5368p pd=3.32u as=0.5368p ps=3.32u w=1.22u l=1u
X2129 a_11424_11115# a_11012_11528# VDD.t1015 VDD.t1014 pfet_05v0 ad=0.3806p pd=2.61u as=0.2249p ps=1.385u w=0.865u l=0.5u
X2130 VDD.t189 a_14124_2727# a_14036_2824# VDD.t188 pfet_05v0 ad=0.5368p pd=3.32u as=0.5368p ps=3.32u w=1.22u l=1u
X2131 VDD.t1652 a_4819_18100# uio_oe[4].t0 VDD.t1651 pfet_05v0 ad=0.5368p pd=3.32u as=0.5368p ps=3.32u w=1.22u l=0.5u
X2132 a_3708_12568# a_3620_12612# VSS VSS nfet_05v0 ad=0.3608p pd=2.52u as=0.3608p ps=2.52u w=0.82u l=1u
X2133 VSS a_21709_808# a_21829_852# VSS nfet_05v0 ad=93.59999f pd=0.88u as=43.2f ps=0.6u w=0.36u l=0.6u
X2134 a_14236_1159# a_14148_1256# VSS VSS nfet_05v0 ad=0.3608p pd=2.52u as=0.3608p ps=2.52u w=0.82u l=1u
X2135 VDD.t1108 a_1020_17272# a_932_17316# VDD.t1107 pfet_05v0 ad=0.5368p pd=3.32u as=0.5368p ps=3.32u w=1.22u l=1u
X2136 VDD.t756 a_16700_4728# a_16612_4772# VDD.t755 pfet_05v0 ad=0.5368p pd=3.32u as=0.5368p ps=3.32u w=1.22u l=1u
X2137 VDD.t1481 a_18044_13703# a_17956_13800# VDD.t1413 pfet_05v0 ad=0.5368p pd=3.32u as=0.5368p ps=3.32u w=1.22u l=1u
X2138 VDD.t704 a_16700_1592# a_16612_1636# VDD.t703 pfet_05v0 ad=0.5368p pd=3.32u as=0.5368p ps=3.32u w=1.22u l=1u
X2139 a_17061_1406# a_16941_808# VDD.t880 VDD.t879 pfet_05v0 ad=61.19999f pd=0.7u as=0.379p ps=2.37u w=0.36u l=0.5u
X2140 VDD.t1692 a_5388_15271# a_5300_15368# VDD.t1691 pfet_05v0 ad=0.5368p pd=3.32u as=0.5368p ps=3.32u w=1.22u l=1u
X2141 a_7180_7431# a_7092_7528# VSS VSS nfet_05v0 ad=0.3608p pd=2.52u as=0.3608p ps=2.52u w=0.82u l=1u
X2142 a_13564_17272# a_13476_17316# VSS VSS nfet_05v0 ad=0.3608p pd=2.52u as=0.3608p ps=2.52u w=0.82u l=1u
X2143 a_9756_15704# a_9668_15748# VSS VSS nfet_05v0 ad=0.3608p pd=2.52u as=0.3608p ps=2.52u w=0.82u l=1u
X2144 a_16611_808# a_16941_808# a_17061_1406# VDD.t881 pfet_05v0 ad=0.3456p pd=2.64u as=61.19999f ps=0.7u w=0.36u l=0.5u
X2145 VDD.t630 a_2812_10567# a_2724_10664# VDD.t629 pfet_05v0 ad=0.5368p pd=3.32u as=0.5368p ps=3.32u w=1.22u l=1u
X2146 a_10032_11875# a_9739_12287# VDD.t2092 VDD.t2091 pfet_05v0 ad=0.352p pd=2.48u as=0.23p ps=1.54u w=0.8u l=0.5u
X2147 VDD.t683 a_3708_15704# a_3620_15748# VDD.t682 pfet_05v0 ad=0.5368p pd=3.32u as=0.5368p ps=3.32u w=1.22u l=1u
X2148 a_13676_4295# a_13588_4392# VSS VSS nfet_05v0 ad=0.3608p pd=2.52u as=0.3608p ps=2.52u w=0.82u l=1u
X2149 VDD.t177 a_14684_4728# a_14596_4772# VDD.t176 pfet_05v0 ad=0.5368p pd=3.32u as=0.5368p ps=3.32u w=1.22u l=1u
X2150 a_19388_1592# a_19300_1636# VSS VSS nfet_05v0 ad=0.3608p pd=2.52u as=0.3608p ps=2.52u w=0.82u l=1u
X2151 VDD.t1891 a_14684_1592# a_14596_1636# VDD.t387 pfet_05v0 ad=0.5368p pd=3.32u as=0.5368p ps=3.32u w=1.22u l=1u
X2152 a_6284_10567# a_6196_10664# VSS VSS nfet_05v0 ad=0.3608p pd=2.52u as=0.3608p ps=2.52u w=0.82u l=1u
X2153 a_13988_12071# a_14392_12243# a_14336_12287# VDD.t1968 pfet_05v0 ad=0.1665p pd=1.285u as=50.4f ps=0.64u w=0.36u l=0.5u
X2154 a_14236_3160# a_14148_3204# VSS VSS nfet_05v0 ad=0.3608p pd=2.52u as=0.3608p ps=2.52u w=0.82u l=1u
X2155 ana_div_chain\[2\]_dff_notouch_.Q a_13280_11485# VSS VSS nfet_05v0 ad=0.2132p pd=1.34u as=0.3608p ps=2.52u w=0.82u l=0.6u
X2156 VSS a_12038_17744# dvo[5].t0 VSS nfet_05v0 ad=0.2132p pd=1.34u as=0.3608p ps=2.52u w=0.82u l=0.6u
X2157 dvo[1].t5 a_14708_12612# VDD.t1646 VDD.t1645 pfet_05v0 ad=0.5368p pd=3.32u as=0.3782p ps=1.84u w=1.22u l=0.5u
X2158 VDD.t130 a_18604_5863# a_18516_5960# VDD.t129 pfet_05v0 ad=0.5368p pd=3.32u as=0.5368p ps=3.32u w=1.22u l=1u
X2159 VDD.t1400 a_6396_12568# a_6308_12612# VDD.t1399 pfet_05v0 ad=0.5368p pd=3.32u as=0.5368p ps=3.32u w=1.22u l=1u
X2160 VDD.t1440 a_5836_13703# a_5748_13800# VDD.t1439 pfet_05v0 ad=0.5368p pd=3.32u as=0.5368p ps=3.32u w=1.22u l=1u
X2161 VDD.t1888 a_18604_2727# a_18516_2824# VDD.t1887 pfet_05v0 ad=0.5368p pd=3.32u as=0.5368p ps=3.32u w=1.22u l=1u
X2162 VDD.t488 a_4828_1159# a_4740_1256# VDD.t487 pfet_05v0 ad=0.5368p pd=3.32u as=0.5368p ps=3.32u w=1.22u l=1u
X2163 a_21516_7431# a_21428_7528# VSS VSS nfet_05v0 ad=0.3608p pd=2.52u as=0.3608p ps=2.52u w=0.82u l=1u
X2164 a_1020_15271# a_932_15368# VSS VSS nfet_05v0 ad=0.3608p pd=2.52u as=0.3608p ps=2.52u w=0.82u l=1u
X2165 a_14664_13487# a_14320_13443# a_13876_13639# VDD.t1368 pfet_05v0 ad=0.1791p pd=1.355u as=0.1665p ps=1.285u w=0.36u l=0.5u
X2166 wire18.I a_13384_11784# VSS VSS nfet_05v0 ad=0.2132p pd=1.34u as=0.3608p ps=2.52u w=0.82u l=0.6u
X2167 VSS a_11478_11784# avo[3].t3 VSS nfet_05v0 ad=0.2132p pd=1.34u as=0.3608p ps=2.52u w=0.82u l=0.6u
X2168 a_1020_12135# a_932_12232# VSS VSS nfet_05v0 ad=0.3608p pd=2.52u as=0.3608p ps=2.52u w=0.82u l=1u
X2169 VDD.t1338 a_6844_14136# a_6756_14180# VDD.t1337 pfet_05v0 ad=0.5368p pd=3.32u as=0.5368p ps=3.32u w=1.22u l=1u
X2170 VDD.t1174 a_14348_9432# a_14260_9476# VDD.t1173 pfet_05v0 ad=0.5368p pd=3.32u as=0.5368p ps=3.32u w=1.22u l=1u
X2171 a_4156_17272# a_4068_17316# VSS VSS nfet_05v0 ad=0.3608p pd=2.52u as=0.3608p ps=2.52u w=0.82u l=1u
X2172 VDD.t513 a_6844_11000# a_6756_11044# VDD.t512 pfet_05v0 ad=0.5368p pd=3.32u as=0.5368p ps=3.32u w=1.22u l=1u
X2173 VDD.t1031 a_3260_15271# a_3172_15368# VDD.t1030 pfet_05v0 ad=0.5368p pd=3.32u as=0.5368p ps=3.32u w=1.22u l=1u
X2174 a_15020_2727# a_14932_2824# VSS VSS nfet_05v0 ad=0.3608p pd=2.52u as=0.3608p ps=2.52u w=0.82u l=1u
X2175 VDD.t1250 a_18380_1159# a_18292_1256# VDD.t1249 pfet_05v0 ad=0.5368p pd=3.32u as=0.5368p ps=3.32u w=1.22u l=1u
X2176 a_6284_4295# a_6196_4392# VSS VSS nfet_05v0 ad=0.3608p pd=2.52u as=0.3608p ps=2.52u w=0.82u l=1u
X2177 VDD.t452 a_21068_8999# a_20980_9096# VDD.t451 pfet_05v0 ad=0.5368p pd=3.32u as=0.5368p ps=3.32u w=1.22u l=1u
X2178 a_9739_12287# a_7764_11911# a_9104_11875# VDD.t1669 pfet_05v0 ad=0.1665p pd=1.285u as=0.1791p ps=1.355u w=0.36u l=0.5u
X2179 VDD.t201 a_7292_4728# a_7204_4772# VDD.t200 pfet_05v0 ad=0.5368p pd=3.32u as=0.5368p ps=3.32u w=1.22u l=1u
X2180 VDD.t582 a_11100_9432# a_11012_9476# VDD.t581 pfet_05v0 ad=0.5368p pd=3.32u as=0.5368p ps=3.32u w=1.22u l=1u
X2181 VDD.t275 a_7292_1592# a_7204_1636# VDD.t274 pfet_05v0 ad=0.5368p pd=3.32u as=0.5368p ps=3.32u w=1.22u l=1u
X2182 VDD.t580 a_20420_14180# avo[0].t1 VDD.t579 pfet_05v0 ad=0.5368p pd=3.32u as=0.3782p ps=1.84u w=1.22u l=0.5u
X2183 VDD.t1206 a_2364_6296# a_2276_6340# VDD.t1205 pfet_05v0 ad=0.5368p pd=3.32u as=0.5368p ps=3.32u w=1.22u l=1u
X2184 a_4604_15704# a_4516_15748# VSS VSS nfet_05v0 ad=0.3608p pd=2.52u as=0.3608p ps=2.52u w=0.82u l=1u
X2185 VDD.t1480 a_18492_13703# a_18404_13800# VDD.t1411 pfet_05v0 ad=0.5368p pd=3.32u as=0.5368p ps=3.32u w=1.22u l=1u
X2186 VDD.t374 a_2364_3160# a_2276_3204# VDD.t373 pfet_05v0 ad=0.5368p pd=3.32u as=0.5368p ps=3.32u w=1.22u l=1u
X2187 a_11478_11784# ana_div_chain\[2\]_dff_notouch_.Q VSS VSS nfet_05v0 ad=0.3608p pd=2.52u as=0.2911p ps=1.53u w=0.82u l=0.6u
X2188 a_11660_4295# a_11572_4392# VSS VSS nfet_05v0 ad=0.3608p pd=2.52u as=0.3608p ps=2.52u w=0.82u l=1u
X2189 VDD.t1084 a_20396_15704# a_20308_15748# VDD.t1083 pfet_05v0 ad=0.5368p pd=3.32u as=0.5368p ps=3.32u w=1.22u l=1u
X2190 VDD.t1424 a_21068_15271# a_20980_15368# VDD.t1423 pfet_05v0 ad=0.5368p pd=3.32u as=0.5368p ps=3.32u w=1.22u l=1u
X2191 VDD.t1373 a_19836_17272# a_19748_17316# VDD.t1372 pfet_05v0 ad=0.5368p pd=3.32u as=0.5368p ps=3.32u w=1.22u l=1u
X2192 VDD.t797 a_18044_12568# a_17956_12612# VDD.t796 pfet_05v0 ad=0.5368p pd=3.32u as=0.5368p ps=3.32u w=1.22u l=1u
X2193 VDD.t1630 a_9420_16839# a_9332_16936# VDD.t1629 pfet_05v0 ad=0.5368p pd=3.32u as=0.5368p ps=3.32u w=1.22u l=1u
X2194 VDD.t1779 a_16812_7431# a_16724_7528# VDD.t1778 pfet_05v0 ad=0.5368p pd=3.32u as=0.5368p ps=3.32u w=1.22u l=1u
X2195 VDD.t2080 a_11478_11784# avo[3].t2 VDD.t2079 pfet_05v0 ad=0.3782p pd=1.84u as=0.5368p ps=3.32u w=1.22u l=0.5u
X2196 VDD.t1219 a_2812_4295# a_2724_4392# VDD.t50 pfet_05v0 ad=0.5368p pd=3.32u as=0.5368p ps=3.32u w=1.22u l=1u
X2197 VSS avo[2].t7 a_10340_13143# VSS nfet_05v0 ad=0.153p pd=1.195u as=0.1584p ps=1.6u w=0.36u l=0.6u
X2198 VDD.t230 a_2812_1159# a_2724_1256# VDD.t229 pfet_05v0 ad=0.5368p pd=3.32u as=0.5368p ps=3.32u w=1.22u l=1u
X2199 VDD.t1757 a_21628_4728# a_21540_4772# VDD.t1756 pfet_05v0 ad=0.5368p pd=3.32u as=0.5368p ps=3.32u w=1.22u l=1u
X2200 VSS a_12038_17744# dvo[5].t2 VSS nfet_05v0 ad=0.2911p pd=1.53u as=0.2132p ps=1.34u w=0.82u l=0.6u
X2201 VDD.t742 a_21628_1592# a_21540_1636# VDD.t741 pfet_05v0 ad=0.5368p pd=3.32u as=0.5368p ps=3.32u w=1.22u l=1u
X2202 VDD.t523 a_17484_15271# a_17396_15368# VDD.t522 pfet_05v0 ad=0.5368p pd=3.32u as=0.5368p ps=3.32u w=1.22u l=1u
X2203 a_15804_11919# ana_div_chain\[1\]_inv_notouch_.ZN a_14880_11875# VSS nfet_05v0 ad=43.2f pd=0.6u as=0.207p ps=1.51u w=0.36u l=0.6u
X2204 a_14124_16839# a_14036_16936# VSS VSS nfet_05v0 ad=0.3608p pd=2.52u as=0.3608p ps=2.52u w=0.82u l=1u
X2205 VDD.t122 a_14572_5863# a_14484_5960# VDD.t121 pfet_05v0 ad=0.5368p pd=3.32u as=0.5368p ps=3.32u w=1.22u l=1u
X2206 VDD.t993 a_7628_10567# a_7540_10664# VDD.t992 pfet_05v0 ad=0.5368p pd=3.32u as=0.5368p ps=3.32u w=1.22u l=1u
X2207 VSS a_7507_18100# a_7507_18100# VSS nfet_05v0 ad=0.3608p pd=2.52u as=0.3608p ps=2.52u w=0.82u l=0.6u
X2208 a_19500_2727# a_19412_2824# VSS VSS nfet_05v0 ad=0.3608p pd=2.52u as=0.3608p ps=2.52u w=0.82u l=1u
X2209 VDD.t1256 a_14572_2727# a_14484_2824# VDD.t1255 pfet_05v0 ad=0.5368p pd=3.32u as=0.5368p ps=3.32u w=1.22u l=1u
X2210 VSS a_16192_15011# ana_div_chain\[3\]_inv_notouch_.I VSS nfet_05v0 ad=0.3608p pd=2.52u as=0.2132p ps=1.34u w=0.82u l=0.6u
X2211 VDD.t173 a_9420_7431# a_9332_7528# VDD.t172 pfet_05v0 ad=0.5368p pd=3.32u as=0.5368p ps=3.32u w=1.22u l=1u
X2212 a_1916_9432# a_1828_9476# VSS VSS nfet_05v0 ad=0.3608p pd=2.52u as=0.3608p ps=2.52u w=0.82u l=1u
X2213 a_21292_15704# a_21204_15748# VSS VSS nfet_05v0 ad=0.3608p pd=2.52u as=0.3608p ps=2.52u w=0.82u l=1u
X2214 a_5836_8999# a_5748_9096# VSS VSS nfet_05v0 ad=0.3608p pd=2.52u as=0.3608p ps=2.52u w=0.82u l=1u
X2215 VDD.t1636 a_15804_15704# a_15716_15748# VDD.t1635 pfet_05v0 ad=0.5368p pd=3.32u as=0.5368p ps=3.32u w=1.22u l=1u
X2216 a_1916_6296# a_1828_6340# VSS VSS nfet_05v0 ad=0.3608p pd=2.52u as=0.3608p ps=2.52u w=0.82u l=1u
X2217 a_5836_5863# a_5748_5960# VSS VSS nfet_05v0 ad=0.3608p pd=2.52u as=0.3608p ps=2.52u w=0.82u l=1u
X2218 wire18.I a_13384_11784# VDD.t1295 VDD.t1294 pfet_05v0 ad=0.3172p pd=1.74u as=0.854p ps=3.84u w=1.22u l=0.5u
X2219 VDD.t1927 a_6844_6296# a_6756_6340# VDD.t1926 pfet_05v0 ad=0.5368p pd=3.32u as=0.5368p ps=3.32u w=1.22u l=1u
X2220 VDD.t911 a_8188_9432# a_8100_9476# VDD.t910 pfet_05v0 ad=0.5368p pd=3.32u as=0.5368p ps=3.32u w=1.22u l=1u
X2221 a_21404_14136# a_21316_14180# VSS VSS nfet_05v0 ad=0.3608p pd=2.52u as=0.3608p ps=2.52u w=0.82u l=1u
X2222 VDD.t1364 a_14768_13443# a_14664_13487# VDD.t1363 pfet_05v0 ad=0.1044p pd=0.94u as=0.1791p ps=1.355u w=0.36u l=0.5u
X2223 VDD.t2004 a_6844_3160# a_6756_3204# VDD.t2003 pfet_05v0 ad=0.5368p pd=3.32u as=0.5368p ps=3.32u w=1.22u l=1u
X2224 VDD.t693 a_11324_14136# a_11236_14180# VDD.t692 pfet_05v0 ad=0.5368p pd=3.32u as=0.5368p ps=3.32u w=1.22u l=1u
X2225 VDD.t702 a_19052_4295# a_18964_4392# VDD.t701 pfet_05v0 ad=0.5368p pd=3.32u as=0.5368p ps=3.32u w=1.22u l=1u
X2226 a_8792_10261# dvo[3].t7 VDD.t646 VDD.t645 pfet_05v0 ad=0.462p pd=2.98u as=0.4015p ps=1.92u w=1.05u l=0.5u
X2227 a_10204_14136# a_10116_14180# VSS VSS nfet_05v0 ad=0.3608p pd=2.52u as=0.3608p ps=2.52u w=0.82u l=1u
X2228 VDD.t216 a_7507_18100# uio_oe[2].t0 VDD.t215 pfet_05v0 ad=0.5368p pd=3.32u as=0.5368p ps=3.32u w=1.22u l=0.5u
X2229 a_15899_15423# a_14336_15368# a_15264_15011# VSS nfet_05v0 ad=93.59999f pd=0.88u as=93.59999f ps=0.88u w=0.36u l=0.6u
X2230 a_4940_16839# a_4852_16936# VSS VSS nfet_05v0 ad=0.3608p pd=2.52u as=0.3608p ps=2.52u w=0.82u l=1u
X2231 a_16700_3160# a_16612_3204# VSS VSS nfet_05v0 ad=0.3608p pd=2.52u as=0.3608p ps=2.52u w=0.82u l=1u
X2232 VDD.t140 a_7180_5863# a_7092_5960# VDD.t139 pfet_05v0 ad=0.5368p pd=3.32u as=0.5368p ps=3.32u w=1.22u l=1u
X2233 VDD.t15 a_7180_2727# a_7092_2824# VDD.t14 pfet_05v0 ad=0.5368p pd=3.32u as=0.5368p ps=3.32u w=1.22u l=1u
X2234 VDD.t1959 a_13340_4728# a_13252_4772# VDD.t1958 pfet_05v0 ad=0.5368p pd=3.32u as=0.5368p ps=3.32u w=1.22u l=1u
X2235 a_1916_16839# a_1828_16936# VSS VSS nfet_05v0 ad=0.3608p pd=2.52u as=0.3608p ps=2.52u w=0.82u l=1u
X2236 VDD.t1436 a_8076_15271# a_7988_15368# VDD.t1435 pfet_05v0 ad=0.5368p pd=3.32u as=0.5368p ps=3.32u w=1.22u l=1u
X2237 VDD.t1410 a_18940_14136# a_18852_14180# VDD.t1409 pfet_05v0 ad=0.5368p pd=3.32u as=0.5368p ps=3.32u w=1.22u l=1u
X2238 a_18044_1592# a_17956_1636# VSS VSS nfet_05v0 ad=0.3608p pd=2.52u as=0.3608p ps=2.52u w=0.82u l=1u
X2239 VDD.t877 a_13340_1592# a_13252_1636# VDD.t712 pfet_05v0 ad=0.5368p pd=3.32u as=0.5368p ps=3.32u w=1.22u l=1u
X2240 a_20060_18407# a_19972_18504# VSS VSS nfet_05v0 ad=0.3608p pd=2.52u as=0.3608p ps=2.52u w=0.82u l=1u
X2241 VDD.t550 a_18940_11000# a_18852_11044# VDD.t549 pfet_05v0 ad=0.5368p pd=3.32u as=0.5368p ps=3.32u w=1.22u l=1u
X2242 a_14724_15055# a_13924_15047# VSS VSS nfet_05v0 ad=43.2f pd=0.6u as=0.1584p ps=1.6u w=0.36u l=0.6u
X2243 VDD.t748 a_20060_1159# a_19972_1256# VDD.t747 pfet_05v0 ad=0.5368p pd=3.32u as=0.5368p ps=3.32u w=1.22u l=1u
X2244 VDD.t1288 a_15916_11000# a_15828_11044# VDD.t1287 pfet_05v0 ad=0.5368p pd=3.32u as=0.5368p ps=3.32u w=1.22u l=1u
X2245 VDD.t2072 a_2364_12135# a_2276_12232# VDD.t1513 pfet_05v0 ad=0.5368p pd=3.32u as=0.5368p ps=3.32u w=1.22u l=1u
X2246 VDD.t132 a_19836_4728# a_19748_4772# VDD.t131 pfet_05v0 ad=0.5368p pd=3.32u as=0.5368p ps=3.32u w=1.22u l=1u
X2247 VDD.t1525 a_3708_8999# a_3620_9096# VDD.t1524 pfet_05v0 ad=0.5368p pd=3.32u as=0.5368p ps=3.32u w=1.22u l=1u
X2248 VDD.t1038 a_12780_7431# a_12692_7528# VDD.t1037 pfet_05v0 ad=0.5368p pd=3.32u as=0.5368p ps=3.32u w=1.22u l=1u
X2249 VDD.t416 a_19836_1592# a_19748_1636# VDD.t415 pfet_05v0 ad=0.5368p pd=3.32u as=0.5368p ps=3.32u w=1.22u l=1u
X2250 a_13988_12071# a_14432_11875# a_14384_11919# VSS nfet_05v0 ad=93.59999f pd=0.88u as=43.2f ps=0.6u w=0.36u l=0.6u
X2251 a_19948_10567# a_19860_10664# VSS VSS nfet_05v0 ad=0.3608p pd=2.52u as=0.3608p ps=2.52u w=0.82u l=1u
X2252 VDD.t1698 a_17862_17744# avo[5].t3 VDD.t1697 pfet_05v0 ad=0.3782p pd=1.84u as=0.5368p ps=3.32u w=1.22u l=0.5u
X2253 a_16700_15704# a_16612_15748# VSS VSS nfet_05v0 ad=0.3608p pd=2.52u as=0.3608p ps=2.52u w=0.82u l=1u
R0 ana_vco_in.n0 ana_vco_in.t1 29.2005
R1 ana_vco_in.n1 ana_vco_in 15.0498
R2 ana_vco_in.n0 ana_vco_in.t0 12.1428
R3 ana_vco_in.n1 ana_vco_in.n0 8.45163
R4 ana_vco_in ana_vco_in.n1 0.062375
R5 dac_vco_in.n0 dac_vco_in.t1 29.2005
R6 dac_vco_in.n1 dac_vco_in 17.0298
R7 dac_vco_in.n0 dac_vco_in.t0 12.1428
R8 dac_vco_in.n1 dac_vco_in.n0 8.45163
R9 dac_vco_in dac_vco_in.n1 0.062375
R10 dvo[3].n9 dvo[3] 29.0898
R11 dvo[3].n0 dvo[3].t7 19.7105
R12 dvo[3].n0 dvo[3].t6 13.3108
R13 dvo[3] dvo[3].t0 8.32599
R14 dvo[3] dvo[3].n4 6.37093
R15 dvo[3].n9 dvo[3].n8 5.5805
R16 dvo[3].n10 dvo[3].n9 4.5005
R17 dvo[3].n6 dvo[3].t3 4.0923
R18 dvo[3].n1 dvo[3].n0 4.0005
R19 dvo[3].n3 dvo[3].n2 2.6005
R20 dvo[3].n2 dvo[3].t5 2.06607
R21 dvo[3].n4 dvo[3].t1 1.99806
R22 dvo[3].n4 dvo[3].t2 1.99806
R23 dvo[3].n2 dvo[3].t4 1.4923
R24 dvo[3].n5 dvo[3] 0.686032
R25 dvo[3].n8 dvo[3].n3 0.394022
R26 dvo[3].n5 dvo[3] 0.222628
R27 dvo[3].n3 dvo[3] 0.17463
R28 dvo[3].n1 dvo[3] 0.1613
R29 dvo[3].n10 dvo[3].n1 0.119754
R30 dvo[3].n7 dvo[3] 0.1165
R31 dvo[3].n8 dvo[3].n7 0.0765
R32 dvo[3].n6 dvo[3] 0.0695517
R33 dvo[3] dvo[3].n6 0.0447241
R34 dvo[3] dvo[3].n10 0.0422073
R35 dvo[3].n7 dvo[3] 0.0354138
R36 dvo[3].n7 dvo[3] 0.0354138
R37 dvo[3].n5 dvo[3] 0.0191207
R38 dvo[3] dvo[3].n5 0.0183448
R39 avo[3].n9 avo[3] 28.3698
R40 avo[3].n6 avo[3].t6 19.7105
R41 avo[3].n10 avo[3].n9 16.0205
R42 avo[3].n6 avo[3].t7 13.3108
R43 avo[3].n5 avo[3].t3 8.29806
R44 avo[3].n1 avo[3].n0 6.3005
R45 avo[3].n9 avo[3].n8 4.5005
R46 avo[3] avo[3].t2 4.13653
R47 avo[3].n7 avo[3].n6 4.00178
R48 avo[3] avo[3].n2 2.71202
R49 avo[3].n2 avo[3].t1 2.06607
R50 avo[3].n0 avo[3].t4 1.99806
R51 avo[3].n0 avo[3].t5 1.99806
R52 avo[3].n2 avo[3].t0 1.4923
R53 avo[3].n4 avo[3].n1 0.756467
R54 avo[3].n3 avo[3] 0.3585
R55 avo[3].n4 avo[3] 0.222628
R56 avo[3].n1 avo[3] 0.123761
R57 avo[3].n3 avo[3] 0.1165
R58 avo[3] avo[3].n10 0.0423966
R59 avo[3] avo[3].n3 0.0354138
R60 avo[3].n3 avo[3] 0.0354138
R61 avo[3].n5 avo[3] 0.028431
R62 avo[3].n7 avo[3] 0.024117
R63 avo[3].n8 avo[3].n7 0.0228729
R64 avo[3].n8 avo[3] 0.019822
R65 avo[3].n4 avo[3] 0.0191207
R66 avo[3] avo[3].n4 0.0183448
R67 avo[3].n10 avo[3].n5 0.00748276
R68 avo[2].n8 avo[2] 26.0298
R69 avo[2].n0 avo[2].t6 19.7105
R70 avo[2].n9 avo[2].n8 19.0125
R71 avo[2].n0 avo[2].t7 13.3108
R72 avo[2].n6 avo[2].t2 8.29806
R73 avo[2].n2 avo[2].n1 6.3005
R74 avo[2].n8 avo[2].n7 4.5005
R75 avo[2] avo[2].t0 4.13653
R76 avo[2].n9 avo[2].n0 4.00178
R77 avo[2] avo[2].n3 2.71202
R78 avo[2].n3 avo[2].t5 2.06607
R79 avo[2].n1 avo[2].t3 1.99806
R80 avo[2].n1 avo[2].t4 1.99806
R81 avo[2].n3 avo[2].t1 1.4923
R82 avo[2].n5 avo[2].n2 0.756467
R83 avo[2].n4 avo[2] 0.3585
R84 avo[2].n5 avo[2] 0.222628
R85 avo[2].n2 avo[2] 0.123761
R86 avo[2].n4 avo[2] 0.1165
R87 avo[2].n7 avo[2] 0.0423966
R88 avo[2] avo[2].n9 0.0411098
R89 avo[2] avo[2].n4 0.0354138
R90 avo[2].n4 avo[2] 0.0354138
R91 avo[2].n6 avo[2] 0.028431
R92 avo[2].n9 avo[2] 0.024117
R93 avo[2].n5 avo[2] 0.0191207
R94 avo[2] avo[2].n5 0.0183448
R95 avo[2].n7 avo[2].n6 0.00748276
R96 dvo[2].n9 dvo[2] 22.6098
R97 dvo[2].n6 dvo[2].t6 19.7105
R98 dvo[2].n6 dvo[2].t7 13.3108
R99 dvo[2].n10 dvo[2].n9 12.0605
R100 dvo[2].n9 dvo[2].n8 9.01257
R101 dvo[2] dvo[2].t3 8.32599
R102 dvo[2] dvo[2].n2 6.37093
R103 dvo[2].n5 dvo[2].t2 4.0923
R104 dvo[2].n7 dvo[2].n6 4.0005
R105 dvo[2].n1 dvo[2].n0 2.6005
R106 dvo[2].n0 dvo[2].t1 2.06607
R107 dvo[2].n2 dvo[2].t4 1.99806
R108 dvo[2].n2 dvo[2].t5 1.99806
R109 dvo[2].n0 dvo[2].t0 1.4923
R110 dvo[2].n3 dvo[2] 0.686032
R111 dvo[2].n4 dvo[2].n1 0.470022
R112 dvo[2].n3 dvo[2] 0.222628
R113 dvo[2].n1 dvo[2] 0.17463
R114 dvo[2].n8 dvo[2] 0.153061
R115 dvo[2].n4 dvo[2] 0.1165
R116 dvo[2] dvo[2].n10 0.0486034
R117 dvo[2].n5 dvo[2] 0.0447241
R118 dvo[2] dvo[2].n4 0.0354138
R119 dvo[2].n4 dvo[2] 0.0354138
R120 dvo[2].n7 dvo[2] 0.0234787
R121 dvo[2].n10 dvo[2].n5 0.0214483
R122 dvo[2].n3 dvo[2] 0.0191207
R123 dvo[2] dvo[2].n3 0.0183448
R124 dvo[2].n8 dvo[2].n7 0.0011383
R125 avo[1].n0 avo[1].t7 19.7105
R126 avo[1].n9 avo[1] 13.9371
R127 avo[1].n0 avo[1].t6 13.3108
R128 avo[1].n10 avo[1].n9 9.91257
R129 avo[1].n9 avo[1].n8 9.38145
R130 avo[1].n5 avo[1].t0 8.29806
R131 avo[1].n4 avo[1].n3 6.3005
R132 avo[1].n8 avo[1].t3 4.0923
R133 avo[1].n1 avo[1].n0 4.0005
R134 avo[1] avo[1].n2 2.71202
R135 avo[1].n2 avo[1].t5 2.06607
R136 avo[1].n3 avo[1].t1 1.99806
R137 avo[1].n3 avo[1].t2 1.99806
R138 avo[1].n2 avo[1].t4 1.4923
R139 avo[1].n6 avo[1].n4 0.756467
R140 avo[1].n7 avo[1] 0.3585
R141 avo[1].n6 avo[1] 0.222628
R142 avo[1].n1 avo[1] 0.1613
R143 avo[1] avo[1].n10 0.153061
R144 avo[1].n4 avo[1] 0.123761
R145 avo[1].n7 avo[1] 0.1165
R146 avo[1].n5 avo[1] 0.0493793
R147 avo[1].n8 avo[1] 0.0447241
R148 avo[1].n7 avo[1] 0.0354138
R149 avo[1] avo[1].n7 0.0354138
R150 avo[1] avo[1].n5 0.028431
R151 avo[1] avo[1].n6 0.0191207
R152 avo[1].n6 avo[1] 0.0183448
R153 avo[1].n10 avo[1].n1 0.0089
R154 avo[0].n4 avo[0] 23.1171
R155 avo[0] avo[0].n3 6.37093
R156 avo[0].n1 avo[0].n0 2.6005
R157 avo[0].n0 avo[0].t0 2.06607
R158 avo[0].n3 avo[0].t2 1.99806
R159 avo[0].n3 avo[0].t3 1.99806
R160 avo[0].n0 avo[0].t1 1.4923
R161 avo[0] avo[0].n4 0.228312
R162 avo[0].n1 avo[0] 0.17463
R163 avo[0] avo[0].n2 0.156622
R164 avo[0].n2 avo[0].n1 0.0963696
R165 avo[0].n4 avo[0] 0.028625
R166 avo[0].n2 avo[0] 0.0216225
R167 dvo[0].n4 dvo[0] 22.9371
R168 dvo[0] dvo[0].n2 6.37093
R169 dvo[0].n1 dvo[0].n0 2.6005
R170 dvo[0].n0 dvo[0].t2 2.06607
R171 dvo[0].n2 dvo[0].t0 1.99806
R172 dvo[0].n2 dvo[0].t1 1.99806
R173 dvo[0].n0 dvo[0].t3 1.4923
R174 dvo[0].n3 dvo[0] 0.264755
R175 dvo[0] dvo[0].n1 0.252492
R176 dvo[0] dvo[0].n4 0.228312
R177 dvo[0].n1 dvo[0] 0.17463
R178 dvo[0].n3 dvo[0] 0.123053
R179 dvo[0] dvo[0].n3 0.0328437
R180 dvo[0].n4 dvo[0] 0.028625
R181 dvo[1].n6 dvo[1].t6 19.7105
R182 dvo[1].n9 dvo[1] 13.5771
R183 dvo[1].n6 dvo[1].t7 13.3108
R184 dvo[1].n10 dvo[1].n9 12.2405
R185 dvo[1].n9 dvo[1].n8 9.0005
R186 dvo[1] dvo[1].t2 8.32599
R187 dvo[1] dvo[1].n2 6.37093
R188 dvo[1].n4 dvo[1].t5 4.0923
R189 dvo[1].n7 dvo[1].n6 4.0005
R190 dvo[1].n1 dvo[1].n0 2.6005
R191 dvo[1].n0 dvo[1].t3 2.06607
R192 dvo[1].n2 dvo[1].t0 1.99806
R193 dvo[1].n2 dvo[1].t1 1.99806
R194 dvo[1].n0 dvo[1].t4 1.4923
R195 dvo[1].n3 dvo[1] 0.686032
R196 dvo[1].n10 dvo[1].n5 0.3005
R197 dvo[1].n1 dvo[1] 0.17463
R198 dvo[1].n11 dvo[1].n1 0.112022
R199 dvo[1].n8 dvo[1].n7 0.111992
R200 dvo[1].n4 dvo[1] 0.0695517
R201 dvo[1].n11 dvo[1].n10 0.0585
R202 dvo[1] dvo[1].n4 0.0447241
R203 dvo[1].n8 dvo[1] 0.0422073
R204 dvo[1].n5 dvo[1] 0.0354138
R205 dvo[1].n5 dvo[1] 0.0354138
R206 dvo[1] dvo[1].n11 0.0235
R207 dvo[1].n7 dvo[1] 0.0234787
R208 dvo[1].n3 dvo[1] 0.0191207
R209 dvo[1] dvo[1].n3 0.0183448
R210 avo[4].n9 avo[4].t6 19.7105
R211 avo[4].n9 avo[4].t7 13.3108
R212 avo[4].n10 avo[4].n8 11.4137
R213 avo[4].n8 avo[4] 9.97713
R214 avo[4].n8 avo[4].n7 9.00748
R215 avo[4].n7 avo[4].t2 8.29806
R216 avo[4] avo[4].n0 6.37093
R217 avo[4].n4 avo[4].t5 4.0923
R218 avo[4].n10 avo[4].n9 4.0005
R219 avo[4].n2 avo[4].n1 2.6005
R220 avo[4].n1 avo[4].t3 2.06607
R221 avo[4].n0 avo[4].t0 1.99806
R222 avo[4].n0 avo[4].t1 1.99806
R223 avo[4].n1 avo[4].t4 1.4923
R224 avo[4].n6 avo[4] 0.686032
R225 avo[4].n5 avo[4].n3 0.3585
R226 avo[4].n2 avo[4] 0.17463
R227 avo[4].n3 avo[4].n2 0.112022
R228 avo[4].n4 avo[4] 0.0695517
R229 avo[4] avo[4].n4 0.0447241
R230 avo[4].n5 avo[4] 0.0354138
R231 avo[4] avo[4].n5 0.0354138
R232 avo[4].n7 avo[4] 0.028431
R233 avo[4].n3 avo[4] 0.0235
R234 avo[4] avo[4].n6 0.0191207
R235 avo[4].n6 avo[4] 0.0183448
R236 avo[4] avo[4].n10 0.0089
R237 dvo[5].n0 dvo[5].t7 19.7105
R238 dvo[5].n0 dvo[5].t6 13.3108
R239 dvo[5].n9 dvo[5] 12.9803
R240 dvo[5].n8 dvo[5].t0 8.29806
R241 dvo[5] dvo[5].n2 6.37093
R242 dvo[5].n10 dvo[5].n9 6.23245
R243 dvo[5].n9 dvo[5].n8 4.50748
R244 dvo[5].n5 dvo[5].t3 4.0923
R245 dvo[5].n1 dvo[5].n0 4.0005
R246 dvo[5].n4 dvo[5].n3 2.6005
R247 dvo[5].n3 dvo[5].t5 2.06607
R248 dvo[5].n2 dvo[5].t1 1.99806
R249 dvo[5].n2 dvo[5].t2 1.99806
R250 dvo[5].n3 dvo[5].t4 1.4923
R251 dvo[5].n7 dvo[5] 0.686032
R252 dvo[5].n6 dvo[5].n4 0.470022
R253 dvo[5].n7 dvo[5] 0.222628
R254 dvo[5].n4 dvo[5] 0.17463
R255 dvo[5].n1 dvo[5] 0.1613
R256 dvo[5].n6 dvo[5] 0.1165
R257 dvo[5].n5 dvo[5] 0.0695517
R258 dvo[5] dvo[5].n5 0.0447241
R259 dvo[5] dvo[5].n10 0.0411098
R260 dvo[5].n6 dvo[5] 0.0354138
R261 dvo[5] dvo[5].n6 0.0354138
R262 dvo[5].n8 dvo[5] 0.028431
R263 dvo[5] dvo[5].n7 0.0191207
R264 dvo[5].n7 dvo[5] 0.0183448
R265 dvo[5].n10 dvo[5].n1 0.0089
R266 dvo[4].n0 dvo[4].t7 19.7105
R267 dvo[4].n10 dvo[4] 16.4571
R268 dvo[4].n0 dvo[4].t6 13.3108
R269 dvo[4] dvo[4].t2 8.32599
R270 dvo[4] dvo[4].n2 6.37093
R271 dvo[4].n10 dvo[4].n9 5.5805
R272 dvo[4].n11 dvo[4].n10 4.5005
R273 dvo[4].n4 dvo[4].t5 4.0923
R274 dvo[4].n1 dvo[4].n0 4.0005
R275 dvo[4].n7 dvo[4].n6 2.6005
R276 dvo[4].n6 dvo[4].t3 2.06607
R277 dvo[4].n2 dvo[4].t0 1.99806
R278 dvo[4].n2 dvo[4].t1 1.99806
R279 dvo[4].n6 dvo[4].t4 1.4923
R280 dvo[4].n3 dvo[4] 0.686032
R281 dvo[4].n9 dvo[4].n5 0.1885
R282 dvo[4].n7 dvo[4] 0.17463
R283 dvo[4].n9 dvo[4].n8 0.1705
R284 dvo[4].n1 dvo[4] 0.1613
R285 dvo[4].n11 dvo[4].n1 0.119754
R286 dvo[4].n8 dvo[4].n7 0.112022
R287 dvo[4].n4 dvo[4] 0.0695517
R288 dvo[4] dvo[4].n4 0.0447241
R289 dvo[4] dvo[4].n11 0.0422073
R290 dvo[4].n5 dvo[4] 0.0354138
R291 dvo[4].n5 dvo[4] 0.0354138
R292 dvo[4].n8 dvo[4] 0.0235
R293 dvo[4].n3 dvo[4] 0.0191207
R294 dvo[4] dvo[4].n3 0.0183448
R295 uio_oe[0].n0 uio_oe[0] 15.7834
R296 uio_oe[0].n0 uio_oe[0].t0 4.0923
R297 uio_oe[0] uio_oe[0].n0 0.148
R298 uio_oe[1].n0 uio_oe[1] 15.7834
R299 uio_oe[1].n0 uio_oe[1].t0 4.0923
R300 uio_oe[1] uio_oe[1].n0 0.148
R301 uio_oe[2].n0 uio_oe[2] 15.7834
R302 uio_oe[2].n0 uio_oe[2].t0 4.0923
R303 uio_oe[2] uio_oe[2].n0 0.148
R304 uio_oe[3].n0 uio_oe[3] 15.7834
R305 uio_oe[3].n0 uio_oe[3].t0 4.0923
R306 uio_oe[3] uio_oe[3].n0 0.148
R307 uio_oe[4].n0 uio_oe[4] 16.1434
R308 uio_oe[4].n0 uio_oe[4].t0 4.0923
R309 uio_oe[4] uio_oe[4].n0 0.148
R310 uio_oe[5].n0 uio_oe[5] 15.7834
R311 uio_oe[5].n0 uio_oe[5].t0 4.0923
R312 uio_oe[5] uio_oe[5].n0 0.148
R313 uio_oe[6].n0 uio_oe[6] 15.7834
R314 uio_oe[6].n0 uio_oe[6].t0 4.0923
R315 uio_oe[6] uio_oe[6].n0 0.148
R316 uio_oe[7].n0 uio_oe[7] 17.0434
R317 uio_oe[7].n0 uio_oe[7].t0 4.0923
R318 uio_oe[7] uio_oe[7].n0 0.148
R319 avo[5].n5 avo[5].t7 19.7105
R320 avo[5].n5 avo[5].t6 13.3108
R321 avo[5].n8 avo[5] 11.9571
R322 avo[5] avo[5].t0 8.32599
R323 avo[5] avo[5].n0 6.37093
R324 avo[5].n9 avo[5].n8 5.9405
R325 avo[5].n8 avo[5].n7 4.5005
R326 avo[5].n2 avo[5].t3 4.0923
R327 avo[5].n6 avo[5].n5 4.0005
R328 avo[5].n4 avo[5].n3 2.6005
R329 avo[5].n3 avo[5].t5 2.06607
R330 avo[5].n0 avo[5].t1 1.99806
R331 avo[5].n0 avo[5].t2 1.99806
R332 avo[5].n3 avo[5].t4 1.4923
R333 avo[5].n1 avo[5] 0.686032
R334 avo[5].n9 avo[5].n4 0.394022
R335 avo[5].n1 avo[5] 0.222628
R336 avo[5].n4 avo[5] 0.17463
R337 avo[5].n6 avo[5] 0.1613
R338 avo[5].n7 avo[5].n6 0.119754
R339 avo[5] avo[5].n10 0.1165
R340 avo[5].n10 avo[5].n9 0.0765
R341 avo[5].n2 avo[5] 0.0695517
R342 avo[5] avo[5].n2 0.0447241
R343 avo[5].n7 avo[5] 0.0422073
R344 avo[5].n10 avo[5] 0.0354138
R345 avo[5].n10 avo[5] 0.0354138
R346 avo[5].n1 avo[5] 0.0191207
R347 avo[5] avo[5].n1 0.0183448
R348 VDD VDD.t770 940.154
R349 VDD.t1522 VDD.t1520 864.865
R350 VDD.t1655 VDD.t1653 864.865
R351 VDD.t217 VDD.t1095 864.865
R352 VDD.t1010 VDD.t1008 864.865
R353 VDD.t1873 VDD.t1871 864.865
R354 VDD.t1864 VDD.t1866 864.865
R355 VDD.t409 VDD.t1864 864.865
R356 VDD.t407 VDD.t409 864.865
R357 VDD.t405 VDD.t407 864.865
R358 VDD.t651 VDD.t405 864.865
R359 VDD.t649 VDD.t651 864.865
R360 VDD.t647 VDD.t649 864.865
R361 VDD.t2051 VDD.t2053 864.865
R362 VDD.t1536 VDD.t1538 864.865
R363 VDD.t672 VDD.t674 864.865
R364 VDD.t1981 VDD.t672 864.865
R365 VDD.t1979 VDD.t1981 864.865
R366 VDD.n1012 VDD.t772 750.966
R367 VDD.n1011 VDD.t1651 743.244
R368 VDD VDD.t1518 723.938
R369 VDD.t1097 VDD 723.938
R370 VDD.t215 VDD 723.938
R371 VDD VDD.t1012 723.938
R372 VDD VDD.t1875 723.938
R373 VDD.n475 VDD.t1645 709.163
R374 VDD.n621 VDD.t1581 709.163
R375 VDD.n715 VDD.t1639 709.163
R376 VDD.n814 VDD.t1703 709.163
R377 VDD.n394 VDD.t1041 705.179
R378 VDD.t1540 VDD 656.371
R379 VDD.n983 VDD.t213 648.649
R380 VDD.t1868 VDD.n980 648.649
R381 VDD.n940 VDD.t647 648.649
R382 VDD.n947 VDD 637.067
R383 VDD.t284 VDD.t297 518.519
R384 VDD.t297 VDD.t0 518.519
R385 VDD.t0 VDD.t255 518.519
R386 VDD.t255 VDD.t229 518.519
R387 VDD.t229 VDD.t6 518.519
R388 VDD.t6 VDD.t242 518.519
R389 VDD.t242 VDD.t289 518.519
R390 VDD.t4 VDD.t153 518.519
R391 VDD.t712 VDD.t4 518.519
R392 VDD.t227 VDD.t712 518.519
R393 VDD.t151 VDD.t227 518.519
R394 VDD.t387 VDD.t151 518.519
R395 VDD.t253 VDD.t387 518.519
R396 VDD.t319 VDD.t253 518.519
R397 VDD.t485 VDD.t246 518.519
R398 VDD.t246 VDD.t423 518.519
R399 VDD.t423 VDD.t373 518.519
R400 VDD.t373 VDD.t389 518.519
R401 VDD.t389 VDD.t248 518.519
R402 VDD.t248 VDD.t782 518.519
R403 VDD.t782 VDD.t504 518.519
R404 VDD.t202 VDD.t36 518.519
R405 VDD.t36 VDD.t866 518.519
R406 VDD.t866 VDD.t104 518.519
R407 VDD.t104 VDD.t50 518.519
R408 VDD.t50 VDD.t334 518.519
R409 VDD.t334 VDD.t137 518.519
R410 VDD.t137 VDD.t26 518.519
R411 VDD.t1786 VDD.t20 518.519
R412 VDD.t20 VDD.t102 518.519
R413 VDD.t102 VDD.t1205 518.519
R414 VDD.t1205 VDD.t345 518.519
R415 VDD.t345 VDD.t72 518.519
R416 VDD.t72 VDD.t106 518.519
R417 VDD.t106 VDD.t1089 518.519
R418 VDD.t936 VDD.t1740 518.519
R419 VDD.t1740 VDD.t1738 518.519
R420 VDD.t1738 VDD.t1736 518.519
R421 VDD.t1736 VDD.t1734 518.519
R422 VDD.t1734 VDD.t268 518.519
R423 VDD.t268 VDD.t311 518.519
R424 VDD.t311 VDD.t309 518.519
R425 VDD.t812 VDD.t810 518.519
R426 VDD.t810 VDD.t1164 518.519
R427 VDD.t1164 VDD.t1162 518.519
R428 VDD.t1162 VDD.t1322 518.519
R429 VDD.t1322 VDD.t1526 518.519
R430 VDD.t1526 VDD.t1524 518.519
R431 VDD.t1524 VDD.t778 518.519
R432 VDD.t959 VDD.t561 518.519
R433 VDD.t561 VDD.t559 518.519
R434 VDD.t559 VDD.t557 518.519
R435 VDD.t557 VDD.t629 518.519
R436 VDD.t629 VDD.t627 518.519
R437 VDD.t627 VDD.t625 518.519
R438 VDD.t625 VDD.t1407 518.519
R439 VDD.t1002 VDD.t1289 518.519
R440 VDD.t1211 VDD.t1209 518.519
R441 VDD.t1209 VDD.t1207 518.519
R442 VDD.t1207 VDD.t1513 518.519
R443 VDD.t1513 VDD.t1511 518.519
R444 VDD.t1511 VDD.t1936 518.519
R445 VDD.t1936 VDD.t663 518.519
R446 VDD.t663 VDD.t661 518.519
R447 VDD.t474 VDD.t476 518.519
R448 VDD.t472 VDD.t474 518.519
R449 VDD.t1413 VDD.t472 518.519
R450 VDD.t1460 VDD.t1458 518.519
R451 VDD.t1458 VDD.t824 518.519
R452 VDD.t824 VDD.t822 518.519
R453 VDD.t822 VDD.t820 518.519
R454 VDD.t820 VDD.t599 518.519
R455 VDD.t599 VDD.t597 518.519
R456 VDD.t597 VDD.t595 518.519
R457 VDD.t1716 VDD.t1714 518.519
R458 VDD.t1714 VDD.t965 518.519
R459 VDD.t965 VDD.t963 518.519
R460 VDD.t963 VDD.t961 518.519
R461 VDD.t961 VDD.t1030 518.519
R462 VDD.t1030 VDD.t682 518.519
R463 VDD.t682 VDD.t680 518.519
R464 VDD.t1107 VDD.t1217 518.519
R465 VDD.t1217 VDD.t1215 518.519
R466 VDD.t1215 VDD.t1213 518.519
R467 VDD.t1213 VDD.t818 518.519
R468 VDD.t818 VDD.t816 518.519
R469 VDD.t816 VDD.t814 518.519
R470 VDD.t814 VDD.t431 518.519
R471 VDD.t729 VDD 498.844
R472 VDD.t741 VDD.t252 468.75
R473 VDD.t1845 VDD.t1540 463.32
R474 VDD.t1520 VDD 451.738
R475 VDD.t1653 VDD 451.738
R476 VDD VDD.t1099 451.738
R477 VDD VDD.t217 451.738
R478 VDD.t1008 VDD 451.738
R479 VDD.t1871 VDD 451.738
R480 VDD VDD.t2051 451.738
R481 VDD VDD.t2049 451.738
R482 VDD VDD.t1536 451.738
R483 VDD VDD.t676 451.738
R484 VDD VDD.t1979 451.738
R485 VDD VDD.t1977 451.738
R486 VDD.t1810 VDD.t1894 447.918
R487 VDD.t1278 VDD.t480 442.13
R488 VDD.t1193 VDD.t1048 442.13
R489 VDD VDD.t1522 413.127
R490 VDD VDD.t1655 413.127
R491 VDD VDD.n1011 413.127
R492 VDD.t1099 VDD 413.127
R493 VDD.t1095 VDD 413.127
R494 VDD.t213 VDD 413.127
R495 VDD VDD.t1010 413.127
R496 VDD VDD.t1873 413.127
R497 VDD VDD.t1868 413.127
R498 VDD.t1866 VDD 413.127
R499 VDD.t2053 VDD 413.127
R500 VDD.t2049 VDD 413.127
R501 VDD.t1538 VDD 413.127
R502 VDD.t676 VDD 413.127
R503 VDD.n946 VDD 413.127
R504 VDD.t674 VDD 413.127
R505 VDD.t1977 VDD 413.127
R506 VDD.t992 VDD.t508 405.094
R507 VDD.t951 VDD.t949 402.779
R508 VDD.t1975 VDD.t1296 402.779
R509 VDD.t1567 VDD 393.519
R510 VDD.n1572 VDD.t289 388.889
R511 VDD.t357 VDD.t1802 388.889
R512 VDD.t8 VDD.t516 388.889
R513 VDD.t1220 VDD.t2101 388.889
R514 VDD.t717 VDD.t498 388.889
R515 VDD.t882 VDD.t1548 388.889
R516 VDD.t14 VDD.t2003 388.889
R517 VDD.t70 VDD.t1949 388.889
R518 VDD.t725 VDD.t934 388.889
R519 VDD.t1189 VDD.t1260 388.889
R520 VDD.t1222 VDD.t133 388.889
R521 VDD.t514 VDD.t361 388.889
R522 VDD.t323 VDD.t1251 388.889
R523 VDD.t1997 VDD.t887 388.889
R524 VDD.t2020 VDD.t721 388.889
R525 VDD.t1191 VDD.t301 388.889
R526 VDD.t784 VDD.t1817 388.889
R527 VDD.t500 VDD.t894 388.889
R528 VDD.t1181 VDD.t188 388.889
R529 VDD.t1938 VDD.t1255 388.889
R530 VDD.t601 VDD.t68 388.889
R531 VDD.t1121 VDD.t12 388.889
R532 VDD.t490 VDD.t1808 388.889
R533 VDD.t1991 VDD.t157 388.889
R534 VDD.t161 VDD.t359 388.889
R535 VDD.t163 VDD.t889 388.889
R536 VDD.t735 VDD.t2 388.889
R537 VDD.t1887 VDD.t184 388.889
R538 VDD.t737 VDD.t884 388.889
R539 VDD.t299 VDD.t295 388.889
R540 VDD.t1989 VDD.t492 388.889
R541 VDD.t1239 VDD.t28 388.889
R542 VDD.t1726 VDD.t135 388.889
R543 VDD.t119 VDD.t76 388.889
R544 VDD.t2068 VDD.t78 388.889
R545 VDD.t1748 VDD.t114 388.889
R546 VDD.t200 VDD.t321 388.889
R547 VDD.t1728 VDD.t355 388.889
R548 VDD.t32 VDD.t1752 388.889
R549 VDD.t30 VDD.t1825 388.889
R550 VDD.t112 VDD.t42 388.889
R551 VDD.t1123 VDD.t1236 388.889
R552 VDD.t463 VDD.t174 388.889
R553 VDD.t699 VDD.t1724 388.889
R554 VDD.t363 VDD.t46 388.889
R555 VDD.t116 VDD.t1035 388.889
R556 VDD.t1958 VDD.t18 388.889
R557 VDD.t147 VDD.t2066 388.889
R558 VDD.t80 VDD.t22 388.889
R559 VDD.t176 VDD.t1942 388.889
R560 VDD.t1902 VDD.t261 388.889
R561 VDD.t40 VDD.t1127 388.889
R562 VDD.t264 VDD.t1951 388.889
R563 VDD.t1183 VDD.t1722 388.889
R564 VDD.t1185 VDD.t149 388.889
R565 VDD.t237 VDD.t2005 388.889
R566 VDD.t780 VDD.t1129 388.889
R567 VDD.t701 VDD.t1945 388.889
R568 VDD.t697 VDD.t170 388.889
R569 VDD.t1187 VDD.t1906 388.889
R570 VDD.t502 VDD.t52 388.889
R571 VDD.t74 VDD.t58 388.889
R572 VDD.t786 VDD.t1746 388.889
R573 VDD.t1762 VDD.t377 388.889
R574 VDD.t139 VDD.t1926 388.889
R575 VDD.t86 VDD.t327 388.889
R576 VDD.t1900 VDD.t1730 388.889
R577 VDD.t369 VDD.t1744 388.889
R578 VDD.t1243 VDD.t1772 388.889
R579 VDD.t1922 VDD.t1770 388.889
R580 VDD.t82 VDD.t1831 388.889
R581 VDD.t365 VDD.t1829 388.889
R582 VDD.t1960 VDD.t2014 388.889
R583 VDD.t303 VDD.t64 388.889
R584 VDD.t62 VDD.t141 388.889
R585 VDD.t857 VDD.t1774 388.889
R586 VDD.t855 VDD.t94 388.889
R587 VDD.t2010 VDD.t121 388.889
R588 VDD.t2008 VDD.t1896 388.889
R589 VDD.t861 VDD.t307 388.889
R590 VDD.t2103 VDD.t1904 388.889
R591 VDD.t38 VDD.t1993 388.889
R592 VDD.t371 VDD.t1139 388.889
R593 VDD.t96 VDD.t1137 388.889
R594 VDD.t1782 VDD.t1087 388.889
R595 VDD.t129 VDD.t1085 388.889
R596 VDD.t1760 VDD.t383 388.889
R597 VDD.t56 VDD.t1999 388.889
R598 VDD.t305 VDD.t127 388.889
R599 VDD.t643 VDD.t385 388.889
R600 VDD.t641 VDD.t1764 388.889
R601 VDD.t605 VDD.t196 388.889
R602 VDD.t603 VDD.t206 388.889
R603 VDD.t1395 VDD.t54 388.889
R604 VDD.t1393 VDD.t123 388.889
R605 VDD.t1224 VDD.t1827 388.889
R606 VDD.t1962 VDD.t1033 388.889
R607 VDD.t172 VDD.t788 388.889
R608 VDD.t66 VDD.t1898 388.889
R609 VDD.t1516 VDD.t2093 388.889
R610 VDD.t1766 VDD.t1932 388.889
R611 VDD.t1915 VDD.t2023 388.889
R612 VDD.t753 VDD.t2059 388.889
R613 VDD.t1953 VDD.t2095 388.889
R614 VDD.t1924 VDD.t337 388.889
R615 VDD.t870 VDD.t204 388.889
R616 VDD.t1768 VDD.t198 388.889
R617 VDD.t182 VDD.t2097 388.889
R618 VDD.t92 VDD.t2099 388.889
R619 VDD.t313 VDD.t1791 388.889
R620 VDD.t1245 VDD.t1778 388.889
R621 VDD.t98 VDD.t853 388.889
R622 VDD.t192 VDD.t190 388.889
R623 VDD.t2057 VDD.t1920 388.889
R624 VDD.t1793 VDD.t100 388.889
R625 VDD.t790 VDD.t1742 388.889
R626 VDD.t194 VDD.t266 388.889
R627 VDD.t984 VDD.t792 388.889
R628 VDD.t774 VDD.t1557 388.889
R629 VDD.t900 VDD.t1555 388.889
R630 VDD.t898 VDD.t690 388.889
R631 VDD.t896 VDD.t688 388.889
R632 VDD.t1843 VDD.t686 388.889
R633 VDD.t1841 VDD.t914 388.889
R634 VDD.t1353 VDD.t910 388.889
R635 VDD.t1429 VDD.t1351 388.889
R636 VDD.t1427 VDD.t1349 388.889
R637 VDD.t585 VDD.t657 388.889
R638 VDD.t581 VDD.t653 388.889
R639 VDD.n292 VDD.t587 388.889
R640 VDD.t902 VDD.t1171 388.889
R641 VDD.t280 VDD.t1169 388.889
R642 VDD.t278 VDD.t1167 388.889
R643 VDD.t276 VDD.t1687 388.889
R644 VDD.t543 VDD.t1685 388.889
R645 VDD.t541 VDD.t1683 388.889
R646 VDD.t451 VDD.t836 388.889
R647 VDD.t449 VDD.t834 388.889
R648 VDD.t2061 VDD.t1403 388.889
R649 VDD.t395 VDD.t1664 388.889
R650 VDD.t391 VDD.t1660 388.889
R651 VDD.t403 VDD.t916 388.889
R652 VDD.t401 VDD.t1314 388.889
R653 VDD.t399 VDD.t1312 388.889
R654 VDD.t2033 VDD.t1310 388.889
R655 VDD.t2031 VDD.t549 388.889
R656 VDD.t2029 VDD.t547 388.889
R657 VDD.t1681 VDD.t1856 388.889
R658 VDD.t1679 VDD.t1854 388.889
R659 VDD.t800 VDD.t1131 388.889
R660 VDD.t798 VDD.t1026 388.889
R661 VDD.t796 VDD.t1024 388.889
R662 VDD.t1230 VDD.t1837 388.889
R663 VDD.t1228 VDD.t1835 388.889
R664 VDD.t1401 VDD.t1833 388.889
R665 VDD.t1397 VDD.t1670 388.889
R666 VDD.t1441 VDD.t573 388.889
R667 VDD.t1439 VDD.t571 388.889
R668 VDD.t1499 VDD.t1341 388.889
R669 VDD.t1497 VDD.t1339 388.889
R670 VDD.t1495 VDD.t1337 388.889
R671 VDD.t2077 VDD.t353 388.889
R672 VDD.t1077 VDD.t1691 388.889
R673 VDD.t1075 VDD.t1689 388.889
R674 VDD.t1073 VDD.t1119 388.889
R675 VDD.t1359 VDD.t1117 388.889
R676 VDD.t1357 VDD.t1115 388.889
R677 VDD.t1355 VDD.t1437 388.889
R678 VDD.t1091 VDD.t1433 388.889
R679 VDD.t1382 VDD.t1318 388.889
R680 VDD.t1380 VDD.t1316 388.889
R681 VDD.t1378 VDD.t1055 388.889
R682 VDD.t1372 VDD.t1599 388.889
R683 VDD.t1347 VDD.t1597 388.889
R684 VDD.t1201 VDD.t1345 388.889
R685 VDD.t1199 VDD.t1343 388.889
R686 VDD.t2055 VDD.t1329 388.889
R687 VDD.t427 VDD.t1143 388.889
R688 VDD.t975 VDD.t555 388.889
R689 VDD.t973 VDD.t553 388.889
R690 VDD.t971 VDD.t551 388.889
R691 VDD.t844 VDD.t832 388.889
R692 VDD.t842 VDD.t830 388.889
R693 VDD.t1631 VDD.t1333 388.889
R694 VDD.t1629 VDD.t1331 388.889
R695 VDD.t1101 VDD.t1391 388.889
R696 VDD.t1455 VDD.t1389 388.889
R697 VDD.t1453 VDD.t1387 388.889
R698 VDD.t569 VDD.t1111 388.889
R699 VDD VDD.n688 377.315
R700 VDD.t250 VDD.t257 373.844
R701 VDD.t1553 VDD.t1533 347.223
R702 VDD.t1060 VDD.t931 346.065
R703 VDD.t461 VDD.t1986 346.065
R704 VDD.t989 VDD.t1069 346.065
R705 VDD.t1017 VDD.t809 329.861
R706 VDD.t1368 VDD.t1365 329.861
R707 VDD.t2089 VDD 324.075
R708 VDD.t457 VDD 324.075
R709 VDD VDD.t1605 324.075
R710 VDD.t847 VDD.t955 312.5
R711 VDD.t526 VDD.t1063 312.5
R712 VDD.t1885 VDD.t1879 303.241
R713 VDD.t421 VDD.t929 303.241
R714 VDD.t969 VDD.t1156 303.241
R715 VDD.t1148 VDD.t1154 303.241
R716 VDD.t623 VDD.t1569 293.981
R717 VDD.t441 VDD.t437 287.038
R718 VDD.n540 VDD.t211 280.094
R719 VDD.t1758 VDD.t1020 277.779
R720 VDD.n395 VDD.t1419 275.464
R721 VDD VDD.t319 270.834
R722 VDD.t504 VDD 270.834
R723 VDD VDD.t1913 270.834
R724 VDD VDD.t259 270.834
R725 VDD.t851 VDD 270.834
R726 VDD.t707 VDD 270.834
R727 VDD VDD.t270 270.834
R728 VDD.t26 VDD 270.834
R729 VDD.t180 VDD 270.834
R730 VDD.t1917 VDD 270.834
R731 VDD.t1823 VDD 270.834
R732 VDD.t1940 VDD 270.834
R733 VDD VDD.t1756 270.834
R734 VDD.t1089 VDD 270.834
R735 VDD VDD.t794 270.834
R736 VDD.t84 VDD 270.834
R737 VDD.t859 VDD 270.834
R738 VDD.t90 VDD 270.834
R739 VDD VDD.t125 270.834
R740 VDD.t309 VDD 270.834
R741 VDD.t1226 VDD 270.834
R742 VDD.t1234 VDD 270.834
R743 VDD VDD.t868 270.834
R744 VDD VDD.t873 270.834
R745 VDD VDD.t48 270.834
R746 VDD.t778 VDD 270.834
R747 VDD VDD.t912 270.834
R748 VDD VDD.t589 270.834
R749 VDD VDD.t537 270.834
R750 VDD VDD.t1475 270.834
R751 VDD.t1407 VDD 270.834
R752 VDD.t393 VDD 270.834
R753 VDD.t512 VDD 270.834
R754 VDD.t510 VDD 270.834
R755 VDD.t1589 VDD 270.834
R756 VDD.t1006 VDD 270.834
R757 VDD.t1004 VDD 270.834
R758 VDD.t1289 VDD 270.834
R759 VDD.t1287 VDD 270.834
R760 VDD.t639 VDD 270.834
R761 VDD VDD.t1621 270.834
R762 VDD VDD.t684 270.834
R763 VDD.t661 VDD 270.834
R764 VDD VDD.t1413 270.834
R765 VDD VDD.t1411 270.834
R766 VDD.t595 VDD 270.834
R767 VDD VDD.t351 270.834
R768 VDD.t680 VDD 270.834
R769 VDD.t1093 VDD 270.834
R770 VDD.t431 VDD 270.834
R771 VDD.t840 VDD 270.834
R772 VDD.t2047 VDD 270.834
R773 VDD VDD.t1109 270.834
R774 VDD.t1635 VDD.t614 266.204
R775 VDD.t466 VDD.t1050 266.204
R776 VDD.t1718 VDD.t2087 263.889
R777 VDD.n87 VDD 261.575
R778 VDD.t155 VDD.t487 259.26
R779 VDD.t16 VDD.t155 259.26
R780 VDD.t282 VDD.t16 259.26
R781 VDD.t330 VDD.t282 259.26
R782 VDD.t1860 VDD.t330 259.26
R783 VDD.t1815 VDD.t1860 259.26
R784 VDD.t317 VDD.t1815 259.26
R785 VDD.t1799 VDD.t317 259.26
R786 VDD.t231 VDD.t1799 259.26
R787 VDD.t719 VDD.t231 259.26
R788 VDD.t274 VDD.t719 259.26
R789 VDD.t332 VDD.t274 259.26
R790 VDD.t723 VDD.t332 259.26
R791 VDD.t1247 VDD.t723 259.26
R792 VDD.t1258 VDD.t1269 259.26
R793 VDD.t1269 VDD.t1795 259.26
R794 VDD.t1795 VDD.t875 259.26
R795 VDD.t875 VDD.t705 259.26
R796 VDD.t705 VDD.t10 259.26
R797 VDD.t10 VDD.t291 259.26
R798 VDD.t291 VDD.t413 259.26
R799 VDD.t413 VDD.t1851 259.26
R800 VDD.t1851 VDD.t286 259.26
R801 VDD.t286 VDD.t1821 259.26
R802 VDD.t1821 VDD.t1262 259.26
R803 VDD.t1262 VDD.t239 259.26
R804 VDD.t239 VDD.t743 259.26
R805 VDD.t743 VDD.t1264 259.26
R806 VDD.t802 VDD.t1811 259.26
R807 VDD.t977 VDD.t1304 259.26
R808 VDD.t1302 VDD.t977 259.26
R809 VDD.t1177 VDD.t1302 259.26
R810 VDD.t1300 VDD.t1177 259.26
R811 VDD.t1175 VDD.t1300 259.26
R812 VDD.t1611 VDD.t1175 259.26
R813 VDD.t1173 VDD.t1611 259.26
R814 VDD.t1609 VDD.t1173 259.26
R815 VDD.t1546 VDD.t1609 259.26
R816 VDD.t1607 VDD.t1546 259.26
R817 VDD.t1544 VDD.t1607 259.26
R818 VDD.t1617 VDD.t1544 259.26
R819 VDD.t1615 VDD.t1542 259.26
R820 VDD.t938 VDD.t940 259.26
R821 VDD.t2079 VDD.t2081 259.26
R822 VDD.n620 VDD.t419 259.26
R823 VDD.t1627 VDD.t520 259.26
R824 VDD.t520 VDD.t1625 259.26
R825 VDD.t1625 VDD.t518 259.26
R826 VDD.t518 VDD.t1623 259.26
R827 VDD.t1623 VDD.t225 259.26
R828 VDD.t225 VDD.t768 259.26
R829 VDD.t223 VDD.t766 259.26
R830 VDD.t766 VDD.t221 259.26
R831 VDD.t221 VDD.t764 259.26
R832 VDD.t1081 VDD.t1425 259.26
R833 VDD.t1423 VDD.t1081 259.26
R834 VDD.t1421 VDD.t1079 259.26
R835 VDD.t397 VDD.t1421 259.26
R836 VDD.t1043 VDD.t397 259.26
R837 VDD.n1428 VDD 252.315
R838 VDD.n1305 VDD 252.315
R839 VDD.n113 VDD 252.315
R840 VDD.n183 VDD 252.315
R841 VDD.n312 VDD 252.315
R842 VDD.n340 VDD 252.315
R843 VDD.n504 VDD 252.315
R844 VDD.n644 VDD 252.315
R845 VDD.n670 VDD 252.315
R846 VDD.t1712 VDD.t1697 252.315
R847 VDD.n819 VDD 252.315
R848 VDD.t1493 VDD.t1491 250
R849 VDD VDD.t284 247.685
R850 VDD VDD.t487 247.685
R851 VDD.t891 VDD 247.685
R852 VDD VDD.t1258 247.685
R853 VDD.t153 VDD 247.685
R854 VDD.t1249 VDD 247.685
R855 VDD.t733 VDD 247.685
R856 VDD.n86 VDD 247.685
R857 VDD.t747 VDD 247.685
R858 VDD.t745 VDD 247.685
R859 VDD VDD.t485 247.685
R860 VDD VDD.t1179 247.685
R861 VDD.t1819 VDD 247.685
R862 VDD.t1483 VDD 247.685
R863 VDD VDD.t411 247.685
R864 VDD VDD.t727 247.685
R865 VDD VDD.t293 247.685
R866 VDD.t1797 VDD 247.685
R867 VDD VDD.t202 247.685
R868 VDD VDD.t88 247.685
R869 VDD VDD.t110 247.685
R870 VDD VDD.t367 247.685
R871 VDD VDD.t379 247.685
R872 VDD VDD.t755 247.685
R873 VDD VDD.t1241 247.685
R874 VDD.t1125 VDD 247.685
R875 VDD VDD.t1786 247.685
R876 VDD VDD.t1750 247.685
R877 VDD.t24 VDD 247.685
R878 VDD VDD.t1955 247.685
R879 VDD VDD.t325 247.685
R880 VDD VDD.t1995 247.685
R881 VDD VDD.t2001 247.685
R882 VDD.t145 VDD 247.685
R883 VDD VDD.t936 247.685
R884 VDD VDD.t632 247.685
R885 VDD VDD.t982 247.685
R886 VDD VDD.t1141 247.685
R887 VDD.t1037 VDD 247.685
R888 VDD.t1754 VDD 247.685
R889 VDD.t1930 VDD 247.685
R890 VDD.t1928 VDD 247.685
R891 VDD VDD.t812 247.685
R892 VDD VDD.t1559 247.685
R893 VDD.t776 VDD 247.685
R894 VDD.t1431 VDD 247.685
R895 VDD.t583 VDD 247.685
R896 VDD.t587 VDD 247.685
R897 VDD.t1304 VDD 247.685
R898 VDD.t1542 VDD 247.685
R899 VDD.t1613 VDD 247.685
R900 VDD.t904 VDD 247.685
R901 VDD.t838 VDD 247.685
R902 VDD.t533 VDD 247.685
R903 VDD VDD.t959 247.685
R904 VDD VDD.t2063 247.685
R905 VDD VDD.t1405 247.685
R906 VDD VDD.n395 247.685
R907 VDD VDD.t1449 247.685
R908 VDD VDD.t1002 247.685
R909 VDD VDD.t1287 247.685
R910 VDD VDD.t1306 247.685
R911 VDD VDD.t918 247.685
R912 VDD VDD.t1858 247.685
R913 VDD.t635 VDD 247.685
R914 VDD VDD.t1211 247.685
R915 VDD VDD.t1232 247.685
R916 VDD VDD.t659 247.685
R917 VDD VDD.t1672 247.685
R918 VDD.t476 VDD 247.685
R919 VDD.t1411 VDD 247.685
R920 VDD.t1409 VDD 247.685
R921 VDD.n643 VDD 247.685
R922 VDD.t233 VDD 247.685
R923 VDD.t343 VDD 247.685
R924 VDD VDD.t1460 247.685
R925 VDD VDD.t575 247.685
R926 VDD.t1443 VDD 247.685
R927 VDD.t2073 VDD 247.685
R928 VDD VDD.t219 247.685
R929 VDD VDD.t1627 247.685
R930 VDD VDD.t223 247.685
R931 VDD.t1425 VDD 247.685
R932 VDD.t1079 VDD 247.685
R933 VDD VDD.t1573 247.685
R934 VDD VDD.t1716 247.685
R935 VDD VDD.t678 247.685
R936 VDD VDD.t1693 247.685
R937 VDD VDD.t1320 247.685
R938 VDD.t1203 VDD 247.685
R939 VDD VDD.t1107 247.685
R940 VDD VDD.t429 247.685
R941 VDD VDD.t1145 247.685
R942 VDD VDD.t1633 247.685
R943 VDD VDD.t1335 247.685
R944 VDD.t1152 VDD.n856 245.37
R945 VDD.t879 VDD.t703 244.214
R946 VDD.t826 VDD 241.899
R947 VDD.t1579 VDD.t1366 240.742
R948 VDD.t957 VDD.t1000 238.427
R949 VDD.t1649 VDD.t1014 236.112
R950 VDD.t443 VDD.t439 236.112
R951 VDD.t529 VDD.t494 236.112
R952 VDD.t1587 VDD.t670 236.112
R953 VDD.t1505 VDD.t1507 236.112
R954 VDD.t1577 VDD.t1370 236.112
R955 VDD.t927 VDD.t925 236.112
R956 VDD.t1057 VDD.t1281 236.112
R957 VDD.t906 VDD.t1983 236.112
R958 VDD.t593 VDD.t1051 236.112
R959 VDD.n983 VDD 235.522
R960 VDD.n980 VDD 235.522
R961 VDD VDD.n940 235.522
R962 VDD VDD.n946 235.522
R963 VDD.t1445 VDD.t443 229.167
R964 VDD.t1647 VDD.t2083 229.167
R965 VDD.t1883 VDD.t1529 224.537
R966 VDD.t1501 VDD.t2089 222.222
R967 VDD.t929 VDD.t692 215.279
R968 VDD.t1987 VDD.t1361 215.279
R969 VDD.t1018 VDD 212.964
R970 VDD VDD.t1039 212.964
R971 VDD.t2085 VDD 212.964
R972 VDD.t1569 VDD 212.964
R973 VDD.t1281 VDD 212.964
R974 VDD VDD.t593 212.964
R975 VDD VDD.t1862 212.964
R976 VDD.t340 VDD.t1368 211.806
R977 VDD.t1135 VDD.t435 208.333
R978 VDD.t433 VDD.t1585 208.333
R979 VDD.t1292 VDD.t567 208.333
R980 VDD.t955 VDD.t849 206.019
R981 VDD.t996 VDD.t953 201.389
R982 VDD.n476 VDD.t1973 201.389
R983 VDD.t1561 VDD.t496 201.389
R984 VDD.t455 VDD.n689 201.389
R985 VDD.t1067 VDD.t1701 201.389
R986 VDD.t881 VDD.t879 194.445
R987 VDD.t715 VDD.t714 194.445
R988 VDD.t1585 VDD.t2037 194.445
R989 VDD VDD.t1489 194.445
R990 VDD.t998 VDD.t532 193.287
R991 VDD VDD.t668 190.972
R992 VDD.t496 VDD 189.815
R993 VDD.t1417 VDD.t1283 187.5
R994 VDD.t1063 VDD.t529 187.5
R995 VDD.n794 VDD.t986 187.5
R996 VDD VDD.t1054 184.029
R997 VDD.t684 VDD.t1969 182.87
R998 VDD.t419 VDD.t927 182.87
R999 VDD.t2035 VDD.t343 182.87
R1000 VDD.t1573 VDD.t612 182.87
R1001 VDD.t953 VDD.t528 180.556
R1002 VDD.t1509 VDD.t665 180.556
R1003 VDD.t1050 VDD.t1487 180.556
R1004 VDD.t1158 VDD.t244 178.242
R1005 VDD.t1862 VDD.t1150 178.242
R1006 VDD.t1285 VDD 175.927
R1007 VDD.t235 VDD 175.927
R1008 VDD.t923 VDD 175.927
R1009 VDD VDD.t455 175.927
R1010 VDD.t437 VDD.t1445 173.612
R1011 VDD.t1601 VDD.t1699 173.612
R1012 VDD.t524 VDD.t531 171.297
R1013 VDD.t1668 VDD.t1531 171.297
R1014 VDD.t1369 VDD.t617 171.297
R1015 VDD.t1985 VDD.t609 171.297
R1016 VDD.t453 VDD 171.297
R1017 VDD.t1710 VDD 171.297
R1018 VDD.t940 VDD.t807 168.982
R1019 VDD.n498 VDD.t526 165.51
R1020 VDD.t612 VDD.n715 165.51
R1021 VDD.t990 VDD.t1964 164.352
R1022 VDD.t1966 VDD.t621 164.352
R1023 VDD VDD.t1845 162.162
R1024 VDD.t1376 VDD.t1603 159.722
R1025 VDD.t1156 VDD.t762 159.722
R1026 VDD.t760 VDD.t1152 159.722
R1027 VDD.t1563 VDD.t577 157.407
R1028 VDD.t1565 VDD.t579 157.407
R1029 VDD.t1133 VDD.t1641 155.094
R1030 VDD.t666 VDD.t1294 152.779
R1031 VDD.t1666 VDD.t1553 152.779
R1032 VDD VDD.t1276 152.779
R1033 VDD.t563 VDD.t2039 152.779
R1034 VDD.t1591 VDD.t645 150.464
R1035 VDD.n503 VDD.t957 150.464
R1036 VDD.n814 VDD.t565 146.992
R1037 VDD.n10 VDD 145.833
R1038 VDD.n1556 VDD 145.833
R1039 VDD.n1370 VDD 145.833
R1040 VDD.n1241 VDD 145.833
R1041 VDD.n244 VDD 145.833
R1042 VDD.n1184 VDD 145.833
R1043 VDD.n419 VDD 145.833
R1044 VDD.t1020 VDD.t944 145.833
R1045 VDD.n566 VDD 145.833
R1046 VDD.n1098 VDD 145.833
R1047 VDD.n746 VDD 145.833
R1048 VDD.n879 VDD 145.833
R1049 VDD.t731 VDD.t250 144.677
R1050 VDD.t1877 VDD.t211 143.519
R1051 VDD.t159 VDD.t1363 143.519
R1052 VDD.n1504 VDD 141.204
R1053 VDD.n1498 VDD 141.204
R1054 VDD VDD.n67 141.204
R1055 VDD VDD.t1266 141.204
R1056 VDD VDD.t1253 141.204
R1057 VDD.t1179 VDD 141.204
R1058 VDD VDD.t725 141.204
R1059 VDD.t1191 VDD 141.204
R1060 VDD.t1808 VDD 141.204
R1061 VDD.t178 VDD 141.204
R1062 VDD.t293 VDD 141.204
R1063 VDD VDD.t186 141.204
R1064 VDD.t88 VDD 141.204
R1065 VDD.t355 VDD 141.204
R1066 VDD.t46 VDD 141.204
R1067 VDD.t1127 VDD 141.204
R1068 VDD.t506 VDD 141.204
R1069 VDD.t1241 VDD 141.204
R1070 VDD VDD.t1947 141.204
R1071 VDD.t1750 VDD 141.204
R1072 VDD.t1900 VDD 141.204
R1073 VDD.t64 VDD 141.204
R1074 VDD.t1904 VDD 141.204
R1075 VDD.t1720 VDD 141.204
R1076 VDD.t2001 VDD 141.204
R1077 VDD VDD.t1788 141.204
R1078 VDD.t632 VDD 141.204
R1079 VDD.t1827 VDD 141.204
R1080 VDD.t2059 VDD 141.204
R1081 VDD VDD.t313 141.204
R1082 VDD VDD.t2017 141.204
R1083 VDD VDD.t1930 141.204
R1084 VDD VDD.t347 141.204
R1085 VDD.t1559 VDD 141.204
R1086 VDD VDD.t1353 141.204
R1087 VDD VDD.t655 141.204
R1088 VDD VDD.t591 141.204
R1089 VDD VDD.t1613 141.204
R1090 VDD VDD.t535 141.204
R1091 VDD VDD.t838 141.204
R1092 VDD VDD.t1473 141.204
R1093 VDD.t2063 VDD 141.204
R1094 VDD.t944 VDD 141.204
R1095 VDD.t804 VDD.n393 141.204
R1096 VDD.t1306 VDD 141.204
R1097 VDD.t637 VDD 141.204
R1098 VDD.t1858 VDD 141.204
R1099 VDD VDD.t1619 141.204
R1100 VDD VDD.n503 141.204
R1101 VDD VDD.t1022 141.204
R1102 VDD.t1232 VDD 141.204
R1103 VDD.t1399 VDD 141.204
R1104 VDD.t1274 VDD 141.204
R1105 VDD VDD.t1462 141.204
R1106 VDD VDD.n620 141.204
R1107 VDD VDD.t2041 141.204
R1108 VDD.t575 VDD 141.204
R1109 VDD VDD.t349 141.204
R1110 VDD VDD.t2073 141.204
R1111 VDD.t609 VDD.t1637 141.204
R1112 VDD.n721 VDD 141.204
R1113 VDD.t678 VDD 141.204
R1114 VDD.t1433 VDD 141.204
R1115 VDD.t1197 VDD 141.204
R1116 VDD VDD.t1347 141.204
R1117 VDD VDD.t1327 141.204
R1118 VDD.t429 VDD 141.204
R1119 VDD.t425 VDD 141.204
R1120 VDD.t1633 VDD 141.204
R1121 VDD.t2045 VDD 141.204
R1122 VDD VDD.t1113 141.204
R1123 VDD VDD.n794 141.204
R1124 VDD.t2091 VDD.t1718 138.889
R1125 VDD.t703 VDD.t315 137.732
R1126 VDD.t435 VDD.t1971 137.732
R1127 VDD.t528 VDD.t998 136.575
R1128 VDD.t44 VDD.t802 135.417
R1129 VDD.t1280 VDD 134.26
R1130 VDD.t1363 VDD.t340 134.26
R1131 VDD VDD.t165 131.945
R1132 VDD VDD.t1595 131.945
R1133 VDD.t1071 VDD.t1705 131.945
R1134 VDD.t1813 VDD.n1572 129.631
R1135 VDD.n1504 VDD.t891 129.631
R1136 VDD.n1499 VDD.t1806 129.631
R1137 VDD.t1264 VDD.n1498 129.631
R1138 VDD.t1889 VDD.n66 129.631
R1139 VDD.t1802 VDD.t1249 129.631
R1140 VDD.t1266 VDD.t357 129.631
R1141 VDD.t1253 VDD.t733 129.631
R1142 VDD.t415 VDD.n86 129.631
R1143 VDD.t516 VDD.t1819 129.631
R1144 VDD.t2101 VDD.t8 129.631
R1145 VDD.t498 VDD.t1220 129.631
R1146 VDD.t1548 VDD.t717 129.631
R1147 VDD.t2003 VDD.t882 129.631
R1148 VDD.t1949 VDD.t14 129.631
R1149 VDD.t1913 VDD.t70 129.631
R1150 VDD.t934 VDD.t739 129.631
R1151 VDD.t1260 VDD.t1483 129.631
R1152 VDD.t133 VDD.t1189 129.631
R1153 VDD.t361 VDD.t1222 129.631
R1154 VDD.t1251 VDD.t514 129.631
R1155 VDD.t887 VDD.t323 129.631
R1156 VDD.t721 VDD.t1997 129.631
R1157 VDD.t259 VDD.t2020 129.631
R1158 VDD.t301 VDD.t2027 129.631
R1159 VDD.t411 VDD.t784 129.631
R1160 VDD.t1817 VDD.t500 129.631
R1161 VDD.t894 VDD.t1181 129.631
R1162 VDD.t188 VDD.t1938 129.631
R1163 VDD.t1255 VDD.t601 129.631
R1164 VDD.t68 VDD.t1121 129.631
R1165 VDD.t12 VDD.t851 129.631
R1166 VDD.t1892 VDD.t490 129.631
R1167 VDD.t727 VDD.t1991 129.631
R1168 VDD.t157 VDD.t161 129.631
R1169 VDD.t359 VDD.t163 129.631
R1170 VDD.t889 VDD.t735 129.631
R1171 VDD.t2 VDD.t1887 129.631
R1172 VDD.t184 VDD.t737 129.631
R1173 VDD.t884 VDD.t707 129.631
R1174 VDD.t1804 VDD.t178 129.631
R1175 VDD.t295 VDD.t1797 129.631
R1176 VDD.t492 VDD.t299 129.631
R1177 VDD.t270 VDD.t1989 129.631
R1178 VDD.t186 VDD.t709 129.631
R1179 VDD.t110 VDD.t1239 129.631
R1180 VDD.t28 VDD.t1726 129.631
R1181 VDD.t135 VDD.t119 129.631
R1182 VDD.t76 VDD.t2068 129.631
R1183 VDD.t78 VDD.t1748 129.631
R1184 VDD.t114 VDD.t200 129.631
R1185 VDD.t321 VDD.t180 129.631
R1186 VDD.t108 VDD.t1728 129.631
R1187 VDD.t367 VDD.t32 129.631
R1188 VDD.t1752 VDD.t30 129.631
R1189 VDD.t1825 VDD.t112 129.631
R1190 VDD.t42 VDD.t1123 129.631
R1191 VDD.t1236 VDD.t463 129.631
R1192 VDD.t174 VDD.t699 129.631
R1193 VDD.t1724 VDD.t1917 129.631
R1194 VDD.t1776 VDD.t363 129.631
R1195 VDD.t379 VDD.t116 129.631
R1196 VDD.t1035 VDD.t1958 129.631
R1197 VDD.t18 VDD.t147 129.631
R1198 VDD.t2066 VDD.t80 129.631
R1199 VDD.t22 VDD.t176 129.631
R1200 VDD.t1942 VDD.t1902 129.631
R1201 VDD.t261 VDD.t1823 129.631
R1202 VDD.t1910 VDD.t40 129.631
R1203 VDD.t755 VDD.t264 129.631
R1204 VDD.t1951 VDD.t1183 129.631
R1205 VDD.t1722 VDD.t1185 129.631
R1206 VDD.t149 VDD.t237 129.631
R1207 VDD.t2005 VDD.t780 129.631
R1208 VDD.t1129 VDD.t701 129.631
R1209 VDD.t1945 VDD.t1940 129.631
R1210 VDD.t131 VDD.t506 129.631
R1211 VDD.t170 VDD.t1125 129.631
R1212 VDD.t1906 VDD.t697 129.631
R1213 VDD.t1756 VDD.t1187 129.631
R1214 VDD.t1947 VDD.t2025 129.631
R1215 VDD.t52 VDD.t24 129.631
R1216 VDD.t58 VDD.t502 129.631
R1217 VDD.t1746 VDD.t74 129.631
R1218 VDD.t377 VDD.t786 129.631
R1219 VDD.t1926 VDD.t1762 129.631
R1220 VDD.t327 VDD.t139 129.631
R1221 VDD.t794 VDD.t86 129.631
R1222 VDD.t1730 VDD.t751 129.631
R1223 VDD.t1955 VDD.t369 129.631
R1224 VDD.t1744 VDD.t1243 129.631
R1225 VDD.t1772 VDD.t1922 129.631
R1226 VDD.t1770 VDD.t82 129.631
R1227 VDD.t1831 VDD.t365 129.631
R1228 VDD.t1829 VDD.t1960 129.631
R1229 VDD.t2014 VDD.t84 129.631
R1230 VDD.t2012 VDD.t303 129.631
R1231 VDD.t325 VDD.t62 129.631
R1232 VDD.t141 VDD.t857 129.631
R1233 VDD.t1774 VDD.t855 129.631
R1234 VDD.t94 VDD.t2010 129.631
R1235 VDD.t121 VDD.t2008 129.631
R1236 VDD.t1896 VDD.t861 129.631
R1237 VDD.t307 VDD.t859 129.631
R1238 VDD.t143 VDD.t2103 129.631
R1239 VDD.t1995 VDD.t38 129.631
R1240 VDD.t1993 VDD.t371 129.631
R1241 VDD.t1139 VDD.t96 129.631
R1242 VDD.t1137 VDD.t1782 129.631
R1243 VDD.t1087 VDD.t129 129.631
R1244 VDD.t1085 VDD.t1760 129.631
R1245 VDD.t383 VDD.t90 129.631
R1246 VDD.t381 VDD.t1720 129.631
R1247 VDD.t1999 VDD.t145 129.631
R1248 VDD.t127 VDD.t56 129.631
R1249 VDD.t125 VDD.t305 129.631
R1250 VDD.t1788 VDD.t167 129.631
R1251 VDD.t982 VDD.t643 129.631
R1252 VDD.t385 VDD.t641 129.631
R1253 VDD.t1764 VDD.t605 129.631
R1254 VDD.t196 VDD.t603 129.631
R1255 VDD.t206 VDD.t1395 129.631
R1256 VDD.t54 VDD.t1393 129.631
R1257 VDD.t123 VDD.t1226 129.631
R1258 VDD.t375 VDD.t1224 129.631
R1259 VDD.t1141 VDD.t1962 129.631
R1260 VDD.t1033 VDD.t172 129.631
R1261 VDD.t788 VDD.t66 129.631
R1262 VDD.t1898 VDD.t1516 129.631
R1263 VDD.t2093 VDD.t1766 129.631
R1264 VDD.t1932 VDD.t1915 129.631
R1265 VDD.t2023 VDD.t1234 129.631
R1266 VDD.t34 VDD.t753 129.631
R1267 VDD.t2095 VDD.t1037 129.631
R1268 VDD.t337 VDD.t1953 129.631
R1269 VDD.t204 VDD.t1924 129.631
R1270 VDD.t198 VDD.t870 129.631
R1271 VDD.t2097 VDD.t1768 129.631
R1272 VDD.t2099 VDD.t182 129.631
R1273 VDD.t868 VDD.t92 129.631
R1274 VDD.t1791 VDD.t864 129.631
R1275 VDD.t1778 VDD.t1754 129.631
R1276 VDD.t853 VDD.t1245 129.631
R1277 VDD.t190 VDD.t98 129.631
R1278 VDD.t1920 VDD.t192 129.631
R1279 VDD.t100 VDD.t2057 129.631
R1280 VDD.t1742 VDD.t1793 129.631
R1281 VDD.t873 VDD.t790 129.631
R1282 VDD.t2017 VDD.t60 129.631
R1283 VDD.t266 VDD.t1928 129.631
R1284 VDD.t792 VDD.t194 129.631
R1285 VDD.t48 VDD.t984 129.631
R1286 VDD.t347 VDD.t1908 129.631
R1287 VDD.t1557 VDD.t776 129.631
R1288 VDD.t1555 VDD.t774 129.631
R1289 VDD.t690 VDD.t900 129.631
R1290 VDD.t688 VDD.t898 129.631
R1291 VDD.t686 VDD.t896 129.631
R1292 VDD.t914 VDD.t1843 129.631
R1293 VDD.t912 VDD.t1841 129.631
R1294 VDD.t910 VDD.t1839 129.631
R1295 VDD.t1351 VDD.t1431 129.631
R1296 VDD.t1349 VDD.t1429 129.631
R1297 VDD.t657 VDD.t1427 129.631
R1298 VDD.t655 VDD.t585 129.631
R1299 VDD.t653 VDD.t583 129.631
R1300 VDD.t591 VDD.t581 129.631
R1301 VDD.t979 VDD.n292 129.631
R1302 VDD.t1171 VDD.t904 129.631
R1303 VDD.t1169 VDD.t902 129.631
R1304 VDD.t1167 VDD.t280 129.631
R1305 VDD.t1687 VDD.t278 129.631
R1306 VDD.t1685 VDD.t276 129.631
R1307 VDD.t1683 VDD.t543 129.631
R1308 VDD.t537 VDD.t541 129.631
R1309 VDD.t535 VDD.t539 129.631
R1310 VDD.t836 VDD.t533 129.631
R1311 VDD.t834 VDD.t451 129.631
R1312 VDD.t1475 VDD.t449 129.631
R1313 VDD.t1473 VDD.t447 129.631
R1314 VDD.t1405 VDD.t2061 129.631
R1315 VDD.t1403 VDD.t395 129.631
R1316 VDD.t1664 VDD.t393 129.631
R1317 VDD.t1662 VDD.t391 129.631
R1318 VDD.t1660 VDD.t512 129.631
R1319 VDD.t994 VDD.t510 129.631
R1320 VDD.t1415 VDD.t1589 129.631
R1321 VDD.t918 VDD.t403 129.631
R1322 VDD.t916 VDD.t401 129.631
R1323 VDD.t1314 VDD.t399 129.631
R1324 VDD.t1312 VDD.t2033 129.631
R1325 VDD.t1310 VDD.t2031 129.631
R1326 VDD.t549 VDD.t2029 129.631
R1327 VDD.t547 VDD.t639 129.631
R1328 VDD.t545 VDD.t637 129.631
R1329 VDD.t1856 VDD.t635 129.631
R1330 VDD.t1854 VDD.t1681 129.631
R1331 VDD.t1621 VDD.t1679 129.631
R1332 VDD.t1619 VDD.t1677 129.631
R1333 VDD.t1131 VDD.t1464 129.631
R1334 VDD.t1026 VDD.t800 129.631
R1335 VDD.t1024 VDD.t798 129.631
R1336 VDD.t1022 VDD.t796 129.631
R1337 VDD VDD.t209 129.631
R1338 VDD.t659 VDD.t1230 129.631
R1339 VDD.t1837 VDD.t1228 129.631
R1340 VDD.t1835 VDD.t1401 129.631
R1341 VDD.t1833 VDD.t1399 129.631
R1342 VDD.t1672 VDD.t1397 129.631
R1343 VDD.t1670 VDD.t1274 129.631
R1344 VDD.t1462 VDD.t233 129.631
R1345 VDD.t2041 VDD.t417 129.631
R1346 VDD.t573 VDD.t1443 129.631
R1347 VDD.t571 VDD.t1441 129.631
R1348 VDD.t1341 VDD.t1439 129.631
R1349 VDD.t1339 VDD.t1499 129.631
R1350 VDD.t1337 VDD.t1497 129.631
R1351 VDD.t353 VDD.t1495 129.631
R1352 VDD.t351 VDD.t2077 129.631
R1353 VDD.t349 VDD.t2075 129.631
R1354 VDD.n688 VDD.t1083 129.631
R1355 VDD.t1693 VDD.t1077 129.631
R1356 VDD.t1691 VDD.t1075 129.631
R1357 VDD.t1689 VDD.t1073 129.631
R1358 VDD.t1119 VDD.t1359 129.631
R1359 VDD.t1117 VDD.t1357 129.631
R1360 VDD.t1115 VDD.t1355 129.631
R1361 VDD.t1437 VDD.t1093 129.631
R1362 VDD.t1435 VDD.t1091 129.631
R1363 VDD.t1320 VDD.t1382 129.631
R1364 VDD.t1318 VDD.t1380 129.631
R1365 VDD.t1316 VDD.t1378 129.631
R1366 VDD.t1055 VDD.t1197 129.631
R1367 VDD.t1599 VDD.t1374 129.631
R1368 VDD.t1597 VDD.t1372 129.631
R1369 VDD.t1345 VDD.t1203 129.631
R1370 VDD.t1343 VDD.t1201 129.631
R1371 VDD.t1329 VDD.t1199 129.631
R1372 VDD.t1327 VDD.t2055 129.631
R1373 VDD.t1145 VDD.t427 129.631
R1374 VDD.t1143 VDD.t975 129.631
R1375 VDD.t555 VDD.t973 129.631
R1376 VDD.t553 VDD.t971 129.631
R1377 VDD.t551 VDD.t844 129.631
R1378 VDD.t832 VDD.t842 129.631
R1379 VDD.t830 VDD.t840 129.631
R1380 VDD.t828 VDD.t425 129.631
R1381 VDD.t1335 VDD.t1631 129.631
R1382 VDD.t1333 VDD.t1629 129.631
R1383 VDD.t1331 VDD.t2047 129.631
R1384 VDD.t1105 VDD.t2045 129.631
R1385 VDD.t1391 VDD.t1103 129.631
R1386 VDD.t1389 VDD.t1101 129.631
R1387 VDD.t1387 VDD.t1455 129.631
R1388 VDD.t1113 VDD.t1453 129.631
R1389 VDD.t1111 VDD.t1451 129.631
R1390 VDD.t1109 VDD.t569 129.631
R1391 VDD.t1419 VDD.t1591 127.316
R1392 VDD.t1593 VDD 127.316
R1393 VDD VDD.t1565 127.316
R1394 VDD VDD.t522 127.316
R1395 VDD.t1707 VDD.t1071 127.316
R1396 VDD.t772 VDD 125.484
R1397 VDD.t770 VDD 125.484
R1398 VDD.t1518 VDD 125.484
R1399 VDD VDD.t1651 125.484
R1400 VDD VDD.t1097 125.484
R1401 VDD VDD.t215 125.484
R1402 VDD.t1012 VDD 125.484
R1403 VDD.t1875 VDD 125.484
R1404 VDD VDD.t1535 125.001
R1405 VDD.t1811 VDD.t272 123.844
R1406 VDD.t809 VDD.t1447 122.686
R1407 VDD.t1535 VDD.t1503 122.686
R1408 VDD.t1069 VDD.t1707 122.686
R1409 VDD.t1968 VDD 120.371
R1410 VDD VDD.n1499 118.056
R1411 VDD.n66 VDD 118.056
R1412 VDD.n67 VDD 118.056
R1413 VDD.t739 VDD 118.056
R1414 VDD.t2027 VDD 118.056
R1415 VDD VDD.t1892 118.056
R1416 VDD VDD.t1804 118.056
R1417 VDD.t709 VDD 118.056
R1418 VDD VDD.t108 118.056
R1419 VDD VDD.t1776 118.056
R1420 VDD VDD.t1910 118.056
R1421 VDD VDD.t131 118.056
R1422 VDD.t2025 VDD 118.056
R1423 VDD.t751 VDD 118.056
R1424 VDD VDD.t2012 118.056
R1425 VDD VDD.t143 118.056
R1426 VDD VDD.t381 118.056
R1427 VDD.t167 VDD 118.056
R1428 VDD VDD.t375 118.056
R1429 VDD VDD.t34 118.056
R1430 VDD.t864 VDD 118.056
R1431 VDD.t60 VDD 118.056
R1432 VDD.t1908 VDD 118.056
R1433 VDD.t1839 VDD 118.056
R1434 VDD.t539 VDD 118.056
R1435 VDD.t447 VDD 118.056
R1436 VDD VDD.t1662 118.056
R1437 VDD VDD.t994 118.056
R1438 VDD VDD.t992 118.056
R1439 VDD VDD.t1415 118.056
R1440 VDD VDD.t946 118.056
R1441 VDD VDD.t545 118.056
R1442 VDD.t1677 VDD 118.056
R1443 VDD.t1464 VDD 118.056
R1444 VDD.t1065 VDD 118.056
R1445 VDD VDD.t1272 118.056
R1446 VDD.t1276 VDD.t695 118.056
R1447 VDD.t417 VDD 118.056
R1448 VDD.t2075 VDD 118.056
R1449 VDD.t482 VDD 118.056
R1450 VDD.t468 VDD.t1493 118.056
R1451 VDD VDD.t1435 118.056
R1452 VDD VDD.t1195 118.056
R1453 VDD.t1374 VDD 118.056
R1454 VDD VDD.t828 118.056
R1455 VDD VDD.t1105 118.056
R1456 VDD VDD.t2043 118.056
R1457 VDD.t1103 VDD 118.056
R1458 VDD.t1451 VDD 118.056
R1459 VDD.t1595 VDD.t1417 115.742
R1460 VDD.t508 VDD.t990 113.427
R1461 VDD.t1507 VDD.t2079 113.427
R1462 VDD.t621 VDD.t1567 113.427
R1463 VDD.t315 VDD 109.954
R1464 VDD.n393 VDD.t445 108.796
R1465 VDD.t1637 VDD.t461 108.796
R1466 VDD.n722 VDD 108.796
R1467 VDD VDD.t804 106.481
R1468 VDD.t1643 VDD.t1133 104.168
R1469 VDD.n723 VDD 103.514
R1470 VDD.t1583 VDD.n621 103.01
R1471 VDD.t577 VDD.t1561 101.853
R1472 VDD.t579 VDD.t1563 101.853
R1473 VDD.t1695 VDD.t1067 101.853
R1474 VDD VDD.n475 100.695
R1475 VDD.t925 VDD.t421 99.5375
R1476 VDD.t219 VDD.t453 99.5375
R1477 VDD.t762 VDD.t1158 99.5375
R1478 VDD.t1150 VDD.t760 99.5375
R1479 VDD.t967 VDD.t1060 98.3801
R1480 VDD.t1964 VDD 97.2227
R1481 VDD.t645 VDD 97.2227
R1482 VDD VDD.t1571 97.2227
R1483 VDD VDD.t1877 97.2227
R1484 VDD VDD.t1966 97.2227
R1485 VDD.t931 VDD 97.2227
R1486 VDD VDD.t967 97.2227
R1487 VDD VDD.t433 97.2227
R1488 VDD VDD.t159 97.2227
R1489 VDD.t607 VDD 97.2227
R1490 VDD VDD.t758 97.2227
R1491 VDD VDD.t1849 97.2227
R1492 VDD.t946 VDD.t1758 94.9079
R1493 VDD.t494 VDD.t1065 94.9079
R1494 VDD.t1641 VDD.t1135 94.9079
R1495 VDD.t1272 VDD.t1285 94.9079
R1496 VDD.n622 VDD.t1577 94.9079
R1497 VDD.t807 VDD.t942 90.2783
R1498 VDD.n542 VDD.n541 89.1209
R1499 VDD VDD.t2035 87.9635
R1500 VDD VDD.t1485 87.9635
R1501 VDD.t1603 VDD 87.9635
R1502 VDD.t531 VDD.n498 85.6486
R1503 VDD.t949 VDD.t996 85.6486
R1504 VDD.n475 VDD.t1972 85.6486
R1505 VDD.n474 VDD.t669 85.6486
R1506 VDD.t1059 VDD.n614 85.6486
R1507 VDD.n621 VDD.t1369 85.6486
R1508 VDD.n715 VDD.t1985 85.6486
R1509 VDD.n689 VDD.t459 85.6486
R1510 VDD.n722 VDD.t1053 85.6486
R1511 VDD.t988 VDD.n814 85.6486
R1512 VDD.t1701 VDD.t1601 85.6486
R1513 VDD VDD.t1649 83.3338
R1514 VDD.t1296 VDD.t666 83.3338
R1515 VDD.t244 VDD.t1160 81.019
R1516 VDD.t1894 VDD.t881 79.8616
R1517 VDD.n614 VDD.t478 79.1715
R1518 VDD.t1697 VDD.t989 77.5468
R1519 VDD.t1533 VDD.n542 76.3894
R1520 VDD.t478 VDD.t1278 76.3894
R1521 VDD.t1048 VDD.t470 76.3894
R1522 VDD.t1605 VDD.t1376 76.3894
R1523 VDD.t942 VDD.n394 75.232
R1524 VDD.t1283 VDD 74.0746
R1525 VDD VDD.t1016 74.0746
R1526 VDD VDD.t2091 74.0746
R1527 VDD.t908 VDD 74.0746
R1528 VDD VDD.t1579 74.0746
R1529 VDD VDD.t1695 74.0746
R1530 VDD VDD.t1148 74.0746
R1531 VDD.t1014 VDD.t938 71.7598
R1532 VDD.t619 VDD.t235 71.7598
R1533 VDD.t692 VDD.t923 71.7598
R1534 VDD.t1487 VDD.t1987 71.7598
R1535 VDD.t2043 VDD.t969 71.7598
R1536 VDD.t272 VDD.t1810 70.6024
R1537 VDD.t1983 VDD 69.4449
R1538 VDD.t1849 VDD.t1292 69.4449
R1539 VDD.t986 VDD 69.4449
R1540 VDD.t1972 VDD.t1643 67.1301
R1541 VDD.t1449 VDD.t1017 65.9727
R1542 VDD.t1669 VDD 65.9727
R1543 VDD.t668 VDD.n540 65.9727
R1544 VDD.t1016 VDD 64.8153
R1545 VDD.t1969 VDD 64.8153
R1546 VDD.t665 VDD.t908 64.8153
R1547 VDD VDD.t457 64.8153
R1548 VDD.t1986 VDD.t1635 63.6579
R1549 VDD.t1054 VDD.t466 63.6579
R1550 VDD.t470 VDD.n723 62.5826
R1551 VDD.t1881 VDD.t1668 62.5005
R1552 VDD.t1366 VDD.t1583 62.5005
R1553 VDD VDD.t1298 60.1857
R1554 VDD VDD.t1666 60.1857
R1555 VDD.t2039 VDD 60.1857
R1556 VDD.t714 VDD.t741 59.0283
R1557 VDD.t1447 VDD.t441 57.8709
R1558 VDD.t1503 VDD.t2085 57.8709
R1559 VDD.t2083 VDD.t1509 57.8709
R1560 VDD.t480 VDD.t1057 57.8709
R1561 VDD.t1051 VDD.t1193 57.8709
R1562 VDD.t459 VDD 55.5561
R1563 VDD.t1361 VDD 55.5561
R1564 VDD.t532 VDD 54.3986
R1565 VDD.t439 VDD.t1006 53.2412
R1566 VDD.t695 VDD.t1059 53.2412
R1567 VDD.t1053 VDD.t468 53.2412
R1568 VDD.t1971 VDD 52.0838
R1569 VDD.t252 VDD.t731 49.769
R1570 VDD.t1973 VDD 46.2968
R1571 VDD.t1370 VDD 46.2968
R1572 VDD VDD.t1505 41.6672
R1573 VDD.t669 VDD 41.6672
R1574 VDD.t1485 VDD 41.6672
R1575 VDD.t1705 VDD.t988 39.3524
R1576 VDD.t1298 VDD.t1587 37.0375
R1577 VDD.t589 VDD.t1018 34.7227
R1578 VDD.t1039 VDD.t1004 34.7227
R1579 VDD.t1571 VDD.n476 34.7227
R1580 VDD.t1529 VDD.t1885 34.7227
R1581 VDD.t445 VDD 32.4079
R1582 VDD.t758 VDD 32.4079
R1583 VDD.t849 VDD.t951 30.0931
R1584 VDD.t2081 VDD.t1647 30.0931
R1585 VDD.t1365 VDD.t563 27.7783
R1586 VDD.t1531 VDD.t1883 25.4635
R1587 VDD VDD.t607 23.1486
R1588 VDD.n541 VDD.t1881 22.4169
R1589 VDD VDD.t808 21.6375
R1590 VDD VDD.t667 21.6375
R1591 VDD VDD.t527 21.6375
R1592 VDD VDD.t1049 21.6375
R1593 VDD.n471 VDD.t1970 21.5338
R1594 VDD.n543 VDD.t1534 21.5338
R1595 VDD.n611 VDD.t1367 21.5338
R1596 VDD.n594 VDD.t1279 21.5338
R1597 VDD.n694 VDD.t613 21.5338
R1598 VDD.n795 VDD.t1711 21.5338
R1599 VDD.t1491 VDD.n721 20.8338
R1600 VDD.n497 VDD.t1061 19.7133
R1601 VDD.n394 VDD.t806 19.2697
R1602 VDD.n474 VDD.t208 19.2697
R1603 VDD.n722 VDD.t933 19.2697
R1604 VDD.n475 VDD.t846 19.268
R1605 VDD.n541 VDD.t1271 19.268
R1606 VDD.n621 VDD.t342 19.268
R1607 VDD.n614 VDD.t694 19.268
R1608 VDD.n715 VDD.t611 19.268
R1609 VDD.n814 VDD.t1709 19.268
R1610 VDD VDD.t1968 18.519
R1611 VDD.t2037 VDD 18.519
R1612 VDD.t1489 VDD.t906 18.519
R1613 VDD.t565 VDD.t1710 18.519
R1614 VDD.n498 VDD.n497 18.2334
R1615 VDD VDD.t715 17.3616
R1616 VDD.n723 VDD.n722 16.5404
R1617 VDD.t1160 VDD 16.2042
R1618 VDD.t670 VDD.t1975 13.8894
R1619 VDD.t2087 VDD.t1501 13.8894
R1620 VDD.n856 VDD.t1154 13.8894
R1621 VDD.t1294 VDD.n474 12.5062
R1622 VDD.n77 VDD.t730 11.8234
R1623 VDD.n68 VDD.t316 11.8234
R1624 VDD VDD.t1813 11.5746
R1625 VDD VDD.t1247 11.5746
R1626 VDD.t1806 VDD 11.5746
R1627 VDD VDD.t1889 11.5746
R1628 VDD VDD.t415 11.5746
R1629 VDD VDD.t747 11.5746
R1630 VDD VDD.t745 11.5746
R1631 VDD VDD.t979 11.5746
R1632 VDD VDD.t1617 11.5746
R1633 VDD VDD.t1615 11.5746
R1634 VDD VDD.t1593 11.5746
R1635 VDD.n394 VDD 11.5746
R1636 VDD.t1000 VDD.t524 11.5746
R1637 VDD VDD.t847 11.5746
R1638 VDD VDD.t1409 11.5746
R1639 VDD VDD.t623 11.5746
R1640 VDD VDD.n643 11.5746
R1641 VDD VDD.t482 11.5746
R1642 VDD.t522 VDD 11.5746
R1643 VDD.t768 VDD 11.5746
R1644 VDD.t764 VDD 11.5746
R1645 VDD VDD.t1083 11.5746
R1646 VDD VDD.t1423 11.5746
R1647 VDD VDD.t1043 11.5746
R1648 VDD.t1195 VDD 11.5746
R1649 VDD.n91 VDD.n90 11.2005
R1650 VDD.n14 VDD.n13 11.2005
R1651 VDD.n1432 VDD.n1431 11.2005
R1652 VDD.n1560 VDD.n1559 11.2005
R1653 VDD.n1309 VDD.n1308 11.2005
R1654 VDD.n1374 VDD.n1373 11.2005
R1655 VDD.n117 VDD.n116 11.2005
R1656 VDD.n1245 VDD.n1244 11.2005
R1657 VDD.n187 VDD.n186 11.2005
R1658 VDD.n248 VDD.n247 11.2005
R1659 VDD.n316 VDD.n315 11.2005
R1660 VDD.n1188 VDD.n1187 11.2005
R1661 VDD.n344 VDD.n343 11.2005
R1662 VDD.n423 VDD.n422 11.2005
R1663 VDD.n570 VDD.n569 11.2005
R1664 VDD.n508 VDD.n507 11.2005
R1665 VDD.n1102 VDD.n1101 11.2005
R1666 VDD.n648 VDD.n647 11.2005
R1667 VDD.n750 VDD.n749 11.2005
R1668 VDD.n674 VDD.n673 11.2005
R1669 VDD.n883 VDD.n882 11.2005
R1670 VDD.n823 VDD.n822 11.2005
R1671 VDD.n948 VDD.n932 11.2005
R1672 VDD.n1015 VDD.n1014 11.2005
R1673 VDD.n84 VDD.n81 10.0805
R1674 VDD.n64 VDD.n61 10.0805
R1675 VDD.n51 VDD.n50 10.0805
R1676 VDD.n1503 VDD.n1501 10.0805
R1677 VDD.n1 VDD.n0 10.0805
R1678 VDD.n1447 VDD.n1423 10.0805
R1679 VDD.n1459 VDD.n1457 10.0805
R1680 VDD.n1555 VDD.n26 10.0805
R1681 VDD.n1324 VDD.n1300 10.0805
R1682 VDD.n1347 VDD.n1344 10.0805
R1683 VDD.n1369 VDD.n1366 10.0805
R1684 VDD.n132 VDD.n108 10.0805
R1685 VDD.n1214 VDD.n1211 10.0805
R1686 VDD.n1240 VDD.n1201 10.0805
R1687 VDD.n182 VDD.n181 10.0805
R1688 VDD.n221 VDD.n155 10.0805
R1689 VDD.n243 VDD.n240 10.0805
R1690 VDD.n311 VDD.n310 10.0805
R1691 VDD.n290 VDD.n287 10.0805
R1692 VDD.n1183 VDD.n260 10.0805
R1693 VDD.n359 VDD.n335 10.0805
R1694 VDD.n391 VDD.n388 10.0805
R1695 VDD.n418 VDD.n415 10.0805
R1696 VDD.n502 VDD.n501 10.0805
R1697 VDD.n565 VDD.n562 10.0805
R1698 VDD.n459 VDD.n458 10.0805
R1699 VDD.n642 VDD.n641 10.0805
R1700 VDD.n1097 VDD.n582 10.0805
R1701 VDD.n618 VDD.n615 10.0805
R1702 VDD.n687 VDD.n665 10.0805
R1703 VDD.n745 VDD.n742 10.0805
R1704 VDD.n719 VDD.n716 10.0805
R1705 VDD.n818 VDD.n817 10.0805
R1706 VDD.n782 VDD.n781 10.0805
R1707 VDD.n878 VDD.n875 10.0805
R1708 VDD.n944 VDD.n941 10.0805
R1709 VDD.n938 VDD.n935 10.0805
R1710 VDD.n907 VDD.n906 10.0805
R1711 VDD.n982 VDD.n905 10.0805
R1712 VDD.n896 VDD.n895 10.0805
R1713 VDD.n93 VDD.n92 9.26571
R1714 VDD.n16 VDD.n15 9.26571
R1715 VDD.n1434 VDD.n1433 9.26571
R1716 VDD.n1562 VDD.n1561 9.26571
R1717 VDD.n1311 VDD.n1310 9.26571
R1718 VDD.n1376 VDD.n1375 9.26571
R1719 VDD.n119 VDD.n118 9.26571
R1720 VDD.n1247 VDD.n1246 9.26571
R1721 VDD.n189 VDD.n188 9.26571
R1722 VDD.n250 VDD.n249 9.26571
R1723 VDD.n318 VDD.n317 9.26571
R1724 VDD.n1190 VDD.n1189 9.26571
R1725 VDD.n346 VDD.n345 9.26571
R1726 VDD.n425 VDD.n424 9.26571
R1727 VDD.n572 VDD.n571 9.26571
R1728 VDD.n510 VDD.n509 9.26571
R1729 VDD.n1104 VDD.n1103 9.26571
R1730 VDD.n650 VDD.n649 9.26571
R1731 VDD.n752 VDD.n751 9.26571
R1732 VDD.n676 VDD.n675 9.26571
R1733 VDD.n885 VDD.n884 9.26571
R1734 VDD.n825 VDD.n824 9.26571
R1735 VDD.n934 VDD.n933 9.26571
R1736 VDD.n1017 VDD.n1016 9.26571
R1737 VDD.t209 VDD 9.25976
R1738 VDD.t617 VDD 9.25976
R1739 VDD.n85 VDD.n75 9.101
R1740 VDD.n65 VDD.n60 9.101
R1741 VDD.n1497 VDD.n1496 9.101
R1742 VDD.n1506 VDD.n1505 9.101
R1743 VDD.n1571 VDD.n1570 9.101
R1744 VDD.n1444 VDD.n1422 9.101
R1745 VDD.n1461 VDD.n1460 9.101
R1746 VDD.n1552 VDD.n25 9.101
R1747 VDD.n1321 VDD.n1299 9.101
R1748 VDD.n1343 VDD.n1333 9.101
R1749 VDD.n1365 VDD.n1356 9.101
R1750 VDD.n129 VDD.n107 9.101
R1751 VDD.n1210 VDD.n141 9.101
R1752 VDD.n1237 VDD.n1200 9.101
R1753 VDD.n179 VDD.n178 9.101
R1754 VDD.n218 VDD.n154 9.101
R1755 VDD.n239 VDD.n230 9.101
R1756 VDD.n308 VDD.n307 9.101
R1757 VDD.n291 VDD.n278 9.101
R1758 VDD.n1180 VDD.n259 9.101
R1759 VDD.n356 VDD.n334 9.101
R1760 VDD.n392 VDD.n372 9.101
R1761 VDD.n414 VDD.n405 9.101
R1762 VDD.n499 VDD.n496 9.101
R1763 VDD.n561 VDD.n552 9.101
R1764 VDD.n539 VDD.n538 9.101
R1765 VDD.n639 VDD.n638 9.101
R1766 VDD.n1094 VDD.n581 9.101
R1767 VDD.n619 VDD.n601 9.101
R1768 VDD.n684 VDD.n664 9.101
R1769 VDD.n741 VDD.n732 9.101
R1770 VDD.n720 VDD.n703 9.101
R1771 VDD.n815 VDD.n813 9.101
R1772 VDD.n855 VDD.n854 9.101
R1773 VDD.n874 VDD.n865 9.101
R1774 VDD.n945 VDD.n925 9.101
R1775 VDD.n939 VDD.n916 9.101
R1776 VDD.n979 VDD.n978 9.101
R1777 VDD.n985 VDD.n984 9.101
R1778 VDD.n1010 VDD.n1009 9.101
R1779 VDD.t257 VDD.t729 8.10235
R1780 VDD.t1879 VDD.t1669 8.10235
R1781 VDD.n368 VDD.t442 7.40883
R1782 VDD.n464 VDD.t1299 7.40883
R1783 VDD.n452 VDD.t2086 7.40883
R1784 VDD.n443 VDD.t1510 7.40883
R1785 VDD.n489 VDD.t954 7.40883
R1786 VDD.n605 VDD.t2040 7.40883
R1787 VDD.n597 VDD.t924 7.40883
R1788 VDD.n690 VDD.t456 7.40883
R1789 VDD.n700 VDD.t1488 7.40883
R1790 VDD.n801 VDD.t1602 7.40883
R1791 VDD.n79 VDD.t716 7.0005
R1792 VDD.n70 VDD.t1812 7.0005
R1793 VDD.t1699 VDD.t1712 6.94494
R1794 VDD VDD.t1582 6.80877
R1795 VDD VDD.t580 6.80877
R1796 VDD.n13 VDD.n10 6.3005
R1797 VDD.n13 VDD.n12 6.3005
R1798 VDD.n14 VDD.n11 6.3005
R1799 VDD.n1572 VDD.n0 6.3005
R1800 VDD.n1568 VDD.n0 6.3005
R1801 VDD.n1569 VDD.n1 6.3005
R1802 VDD.n1504 VDD.n1503 6.3005
R1803 VDD.n1503 VDD.n1502 6.3005
R1804 VDD.n1501 VDD.n1500 6.3005
R1805 VDD.n1498 VDD.n50 6.3005
R1806 VDD.n1494 VDD.n50 6.3005
R1807 VDD.n1495 VDD.n51 6.3005
R1808 VDD.n66 VDD.n61 6.3005
R1809 VDD.n62 VDD.n61 6.3005
R1810 VDD.n64 VDD.n63 6.3005
R1811 VDD.n86 VDD.n81 6.3005
R1812 VDD.n82 VDD.n81 6.3005
R1813 VDD.n84 VDD.n83 6.3005
R1814 VDD.n90 VDD.n87 6.3005
R1815 VDD.n90 VDD.n89 6.3005
R1816 VDD.n91 VDD.n88 6.3005
R1817 VDD.n1445 VDD.n1423 6.3005
R1818 VDD.t293 VDD.n1447 6.3005
R1819 VDD.n1447 VDD.n1446 6.3005
R1820 VDD.n1559 VDD.n1556 6.3005
R1821 VDD.n1559 VDD.n1558 6.3005
R1822 VDD.n1560 VDD.n1557 6.3005
R1823 VDD.t1179 VDD.n1555 6.3005
R1824 VDD.n1555 VDD.n1554 6.3005
R1825 VDD.n1553 VDD.n26 6.3005
R1826 VDD.t1191 VDD.n1459 6.3005
R1827 VDD.n1459 VDD.n1458 6.3005
R1828 VDD.n1457 VDD.n1456 6.3005
R1829 VDD.n1431 VDD.n1428 6.3005
R1830 VDD.n1431 VDD.n1430 6.3005
R1831 VDD.n1432 VDD.n1429 6.3005
R1832 VDD.n1322 VDD.n1300 6.3005
R1833 VDD.t1241 VDD.n1324 6.3005
R1834 VDD.n1324 VDD.n1323 6.3005
R1835 VDD.n1373 VDD.n1370 6.3005
R1836 VDD.n1373 VDD.n1372 6.3005
R1837 VDD.n1374 VDD.n1371 6.3005
R1838 VDD.t88 VDD.n1369 6.3005
R1839 VDD.n1369 VDD.n1368 6.3005
R1840 VDD.n1367 VDD.n1366 6.3005
R1841 VDD.t46 VDD.n1347 6.3005
R1842 VDD.n1347 VDD.n1346 6.3005
R1843 VDD.n1345 VDD.n1344 6.3005
R1844 VDD.n1308 VDD.n1305 6.3005
R1845 VDD.n1308 VDD.n1307 6.3005
R1846 VDD.n1309 VDD.n1306 6.3005
R1847 VDD.n130 VDD.n108 6.3005
R1848 VDD.t2001 VDD.n132 6.3005
R1849 VDD.n132 VDD.n131 6.3005
R1850 VDD.n1244 VDD.n1241 6.3005
R1851 VDD.n1244 VDD.n1243 6.3005
R1852 VDD.n1245 VDD.n1242 6.3005
R1853 VDD.t1750 VDD.n1240 6.3005
R1854 VDD.n1240 VDD.n1239 6.3005
R1855 VDD.n1238 VDD.n1201 6.3005
R1856 VDD.t64 VDD.n1214 6.3005
R1857 VDD.n1214 VDD.n1213 6.3005
R1858 VDD.n1212 VDD.n1211 6.3005
R1859 VDD.n116 VDD.n113 6.3005
R1860 VDD.n116 VDD.n115 6.3005
R1861 VDD.n117 VDD.n114 6.3005
R1862 VDD.n181 VDD.n180 6.3005
R1863 VDD.t1930 VDD.n182 6.3005
R1864 VDD.n182 VDD.n173 6.3005
R1865 VDD.n247 VDD.n244 6.3005
R1866 VDD.n247 VDD.n246 6.3005
R1867 VDD.n248 VDD.n245 6.3005
R1868 VDD.t632 VDD.n243 6.3005
R1869 VDD.n243 VDD.n242 6.3005
R1870 VDD.n241 VDD.n240 6.3005
R1871 VDD.t2059 VDD.n221 6.3005
R1872 VDD.n221 VDD.n220 6.3005
R1873 VDD.n219 VDD.n155 6.3005
R1874 VDD.n186 VDD.n183 6.3005
R1875 VDD.n186 VDD.n185 6.3005
R1876 VDD.n187 VDD.n184 6.3005
R1877 VDD.n310 VDD.n309 6.3005
R1878 VDD.t838 VDD.n311 6.3005
R1879 VDD.n311 VDD.n302 6.3005
R1880 VDD.n1187 VDD.n1184 6.3005
R1881 VDD.n1187 VDD.n1186 6.3005
R1882 VDD.n1188 VDD.n1185 6.3005
R1883 VDD.t1559 VDD.n1183 6.3005
R1884 VDD.n1183 VDD.n1182 6.3005
R1885 VDD.n1181 VDD.n260 6.3005
R1886 VDD.n292 VDD.n287 6.3005
R1887 VDD.n288 VDD.n287 6.3005
R1888 VDD.n290 VDD.n289 6.3005
R1889 VDD.n315 VDD.n312 6.3005
R1890 VDD.n315 VDD.n314 6.3005
R1891 VDD.n316 VDD.n313 6.3005
R1892 VDD.n422 VDD.n419 6.3005
R1893 VDD.n422 VDD.n421 6.3005
R1894 VDD.n423 VDD.n420 6.3005
R1895 VDD.t2063 VDD.n418 6.3005
R1896 VDD.n418 VDD.n417 6.3005
R1897 VDD.n416 VDD.n415 6.3005
R1898 VDD.n393 VDD.n388 6.3005
R1899 VDD.n389 VDD.n388 6.3005
R1900 VDD.n391 VDD.n390 6.3005
R1901 VDD.t1858 VDD.n359 6.3005
R1902 VDD.n359 VDD.n358 6.3005
R1903 VDD.n357 VDD.n335 6.3005
R1904 VDD.n343 VDD.n340 6.3005
R1905 VDD.n343 VDD.n342 6.3005
R1906 VDD.n344 VDD.n341 6.3005
R1907 VDD.n501 VDD.n500 6.3005
R1908 VDD.n503 VDD.n502 6.3005
R1909 VDD.n502 VDD.n487 6.3005
R1910 VDD.n507 VDD.n504 6.3005
R1911 VDD.n507 VDD.n506 6.3005
R1912 VDD.n508 VDD.n505 6.3005
R1913 VDD.n540 VDD.n458 6.3005
R1914 VDD.n536 VDD.n458 6.3005
R1915 VDD.n537 VDD.n459 6.3005
R1916 VDD.n569 VDD.n566 6.3005
R1917 VDD.n569 VDD.n568 6.3005
R1918 VDD.n570 VDD.n567 6.3005
R1919 VDD.t1232 VDD.n565 6.3005
R1920 VDD.n565 VDD.n564 6.3005
R1921 VDD.n563 VDD.n562 6.3005
R1922 VDD.n641 VDD.n640 6.3005
R1923 VDD.n643 VDD.n642 6.3005
R1924 VDD.n642 VDD.n631 6.3005
R1925 VDD.n647 VDD.n644 6.3005
R1926 VDD.n647 VDD.n646 6.3005
R1927 VDD.n648 VDD.n645 6.3005
R1928 VDD.n620 VDD.n615 6.3005
R1929 VDD.n616 VDD.n615 6.3005
R1930 VDD.n618 VDD.n617 6.3005
R1931 VDD.n1101 VDD.n1098 6.3005
R1932 VDD.n1101 VDD.n1100 6.3005
R1933 VDD.n1102 VDD.n1099 6.3005
R1934 VDD.t575 VDD.n1097 6.3005
R1935 VDD.n1097 VDD.n1096 6.3005
R1936 VDD.n1095 VDD.n582 6.3005
R1937 VDD.n685 VDD.n665 6.3005
R1938 VDD.n688 VDD.n687 6.3005
R1939 VDD.n687 VDD.n686 6.3005
R1940 VDD.n673 VDD.n670 6.3005
R1941 VDD.n673 VDD.n672 6.3005
R1942 VDD.n674 VDD.n671 6.3005
R1943 VDD.n721 VDD.n716 6.3005
R1944 VDD.n717 VDD.n716 6.3005
R1945 VDD.n719 VDD.n718 6.3005
R1946 VDD.n749 VDD.n746 6.3005
R1947 VDD.n749 VDD.n748 6.3005
R1948 VDD.n750 VDD.n747 6.3005
R1949 VDD.t678 VDD.n745 6.3005
R1950 VDD.n745 VDD.n744 6.3005
R1951 VDD.n743 VDD.n742 6.3005
R1952 VDD.n817 VDD.n816 6.3005
R1953 VDD.t1347 VDD.n818 6.3005
R1954 VDD.n818 VDD.n808 6.3005
R1955 VDD.n822 VDD.n819 6.3005
R1956 VDD.n822 VDD.n821 6.3005
R1957 VDD.n823 VDD.n820 6.3005
R1958 VDD.n882 VDD.n879 6.3005
R1959 VDD.n882 VDD.n881 6.3005
R1960 VDD.n883 VDD.n880 6.3005
R1961 VDD.t429 VDD.n878 6.3005
R1962 VDD.n878 VDD.n877 6.3005
R1963 VDD.n876 VDD.n875 6.3005
R1964 VDD.n856 VDD.n781 6.3005
R1965 VDD.n852 VDD.n781 6.3005
R1966 VDD.n853 VDD.n782 6.3005
R1967 VDD.n932 VDD.n931 6.3005
R1968 VDD.n948 VDD.n947 6.3005
R1969 VDD.n949 VDD.n948 6.3005
R1970 VDD.n1014 VDD.n1012 6.3005
R1971 VDD.n1014 VDD.n1013 6.3005
R1972 VDD.n1015 VDD.n894 6.3005
R1973 VDD.n1011 VDD.n895 6.3005
R1974 VDD.n1007 VDD.n895 6.3005
R1975 VDD.n1008 VDD.n896 6.3005
R1976 VDD.n983 VDD.n982 6.3005
R1977 VDD.n982 VDD.n981 6.3005
R1978 VDD.n905 VDD.n904 6.3005
R1979 VDD.n980 VDD.n906 6.3005
R1980 VDD.n976 VDD.n906 6.3005
R1981 VDD.n977 VDD.n907 6.3005
R1982 VDD.n940 VDD.n935 6.3005
R1983 VDD.n936 VDD.n935 6.3005
R1984 VDD.n938 VDD.n937 6.3005
R1985 VDD.n946 VDD.n941 6.3005
R1986 VDD.n942 VDD.n941 6.3005
R1987 VDD.n944 VDD.n943 6.3005
R1988 VDD.n373 VDD.t805 6.22272
R1989 VDD.n468 VDD.t1134 6.22272
R1990 VDD.n455 VDD.t1532 6.22272
R1991 VDD.n460 VDD.t210 6.22272
R1992 VDD.n485 VDD.t525 6.22272
R1993 VDD.n608 VDD.t618 6.22272
R1994 VDD.n595 VDD.t1277 6.22272
R1995 VDD.n692 VDD.t610 6.22272
R1996 VDD.n704 VDD.t1494 6.22272
R1997 VDD.n798 VDD.t1072 6.22272
R1998 VDD.t165 VDD.t826 5.78754
R1999 VDD.n365 VDD.t440 5.58411
R2000 VDD.n462 VDD.t1295 5.58411
R2001 VDD.n449 VDD.t2090 5.58411
R2002 VDD.n448 VDD.t1506 5.58411
R2003 VDD.n494 VDD.t956 5.58411
R2004 VDD.n603 VDD.t2036 5.58411
R2005 VDD.n600 VDD.t928 5.58411
R2006 VDD.n662 VDD.t458 5.58411
R2007 VDD.n695 VDD.t1490 5.58411
R2008 VDD.n805 VDD.t1606 5.58411
R2009 VDD VDD.n385 5.34344
R2010 VDD VDD.n384 5.34344
R2011 VDD VDD.n457 5.34344
R2012 VDD VDD.n454 5.34344
R2013 VDD VDD.n467 5.34344
R2014 VDD VDD.n470 5.34344
R2015 VDD VDD.n774 5.34344
R2016 VDD VDD.n771 5.34344
R2017 VDD VDD.n847 5.34344
R2018 VDD VDD.n783 5.34344
R2019 VDD VDD.n796 5.34344
R2020 VDD VDD.n797 5.34344
R2021 VDD VDD.n800 5.34344
R2022 VDD VDD.n803 5.34344
R2023 VDD VDD.n610 5.31697
R2024 VDD VDD.n632 5.31697
R2025 VDD VDD.n397 5.28785
R2026 VDD VDD.n380 5.28785
R2027 VDD VDD.n451 5.28785
R2028 VDD VDD.n607 5.28785
R2029 VDD VDD.n791 5.28785
R2030 VDD VDD.n378 5.23756
R2031 VDD VDD.n466 5.23756
R2032 VDD VDD.n482 5.23756
R2033 VDD VDD.n708 5.23756
R2034 VDD VDD.n373 5.23094
R2035 VDD VDD.n460 5.23094
R2036 VDD VDD.n485 5.23094
R2037 VDD VDD.n704 5.23094
R2038 VDD.n80 VDD.n79 5.2005
R2039 VDD.n78 VDD.n77 5.2005
R2040 VDD.n71 VDD.n70 5.2005
R2041 VDD.n69 VDD.n68 5.2005
R2042 VDD.n375 VDD.n374 5.2005
R2043 VDD.n377 VDD.n376 5.2005
R2044 VDD.n387 VDD.n386 5.2005
R2045 VDD.n369 VDD.n368 5.2005
R2046 VDD.n473 VDD.n472 5.2005
R2047 VDD.n469 VDD.n468 5.2005
R2048 VDD.n465 VDD.n464 5.2005
R2049 VDD.n533 VDD.n532 5.2005
R2050 VDD.n446 VDD.n445 5.2005
R2051 VDD.n453 VDD.n452 5.2005
R2052 VDD.n456 VDD.n455 5.2005
R2053 VDD.n545 VDD.n544 5.2005
R2054 VDD.n444 VDD.n443 5.2005
R2055 VDD.n490 VDD.n489 5.2005
R2056 VDD.n636 VDD.n635 5.2005
R2057 VDD.n634 VDD.n633 5.2005
R2058 VDD.n630 VDD.n629 5.2005
R2059 VDD.n613 VDD.n612 5.2005
R2060 VDD.n609 VDD.n608 5.2005
R2061 VDD.n606 VDD.n605 5.2005
R2062 VDD.n598 VDD.n597 5.2005
R2063 VDD.n596 VDD.n595 5.2005
R2064 VDD.n593 VDD.n592 5.2005
R2065 VDD.n691 VDD.n690 5.2005
R2066 VDD.n693 VDD.n692 5.2005
R2067 VDD.n697 VDD.n696 5.2005
R2068 VDD.n701 VDD.n700 5.2005
R2069 VDD.n802 VDD.n801 5.2005
R2070 VDD.n799 VDD.n798 5.2005
R2071 VDD.n793 VDD.n792 5.2005
R2072 VDD.n849 VDD.n848 5.2005
R2073 VDD.n773 VDD.n772 5.2005
R2074 VDD.n921 VDD.n920 5.2005
R2075 VDD.n79 VDD.t827 5.05606
R2076 VDD.n77 VDD.t251 5.05606
R2077 VDD.n70 VDD.t803 5.05606
R2078 VDD.n68 VDD.t880 5.05606
R2079 VDD.n373 VDD.t446 5.05606
R2080 VDD.n468 VDD.t1136 5.05606
R2081 VDD.n455 VDD.t1530 5.05606
R2082 VDD.n460 VDD.t212 5.05606
R2083 VDD.n485 VDD.t958 5.05606
R2084 VDD.n608 VDD.t1364 5.05606
R2085 VDD.n595 VDD.t932 5.05606
R2086 VDD.n692 VDD.t462 5.05606
R2087 VDD.n704 VDD.t1492 5.05606
R2088 VDD.n798 VDD.t1070 5.05606
R2089 VDD.n1026 VDD.n1025 4.9415
R2090 VDD.n1045 VDD.n770 4.9415
R2091 VDD.n957 VDD.n655 4.9415
R2092 VDD VDD.t1280 4.63013
R2093 VDD.t614 VDD 4.63013
R2094 VDD.t567 VDD 4.63013
R2095 VDD.n1027 VDD.n1026 4.5005
R2096 VDD.n753 VDD.n573 4.5005
R2097 VDD.n1106 VDD.n1105 4.5005
R2098 VDD.n1108 VDD.n1107 4.5005
R2099 VDD.n426 VDD.n251 4.5005
R2100 VDD.n1192 VDD.n1191 4.5005
R2101 VDD.n1251 VDD.n1250 4.5005
R2102 VDD.n1249 VDD.n1248 4.5005
R2103 VDD.n1377 VDD.n17 4.5005
R2104 VDD.n1564 VDD.n1563 4.5005
R2105 VDD.n1566 VDD.n1565 4.5005
R2106 VDD.n1485 VDD.n1484 4.5005
R2107 VDD.n1532 VDD.n1531 4.5005
R2108 VDD.n1045 VDD.n1044 4.5005
R2109 VDD.n1047 VDD.n1046 4.5005
R2110 VDD.n1078 VDD.n442 4.5005
R2111 VDD.n1124 VDD.n1123 4.5005
R2112 VDD.n1126 VDD.n1125 4.5005
R2113 VDD.n1162 VDD.n146 4.5005
R2114 VDD.n1269 VDD.n1268 4.5005
R2115 VDD.n1271 VDD.n1270 4.5005
R2116 VDD.n1394 VDD.n42 4.5005
R2117 VDD.n1534 VDD.n1533 4.5005
R2118 VDD.n1483 VDD.n1482 4.5005
R2119 VDD.n1414 VDD.n1413 4.5005
R2120 VDD.n1291 VDD.n1290 4.5005
R2121 VDD.n197 VDD.n99 4.5005
R2122 VDD.n1144 VDD.n1143 4.5005
R2123 VDD.n1142 VDD.n1141 4.5005
R2124 VDD.n518 VDD.n326 4.5005
R2125 VDD.n1066 VDD.n1065 4.5005
R2126 VDD.n1064 VDD.n1063 4.5005
R2127 VDD.n833 VDD.n655 4.5005
R2128 VDD VDD.t489 4.36035
R2129 VDD VDD.t298 4.36035
R2130 VDD VDD.t1 4.36035
R2131 VDD VDD.t256 4.36035
R2132 VDD VDD.t465 4.36035
R2133 VDD VDD.t886 4.36035
R2134 VDD VDD.t243 4.36035
R2135 VDD VDD.t1853 4.36035
R2136 VDD VDD.t1814 4.36035
R2137 VDD VDD.t156 4.36035
R2138 VDD VDD.t283 4.36035
R2139 VDD VDD.t1861 4.36035
R2140 VDD VDD.t318 4.36035
R2141 VDD VDD.t232 4.36035
R2142 VDD VDD.t275 4.36035
R2143 VDD VDD.t724 4.36035
R2144 VDD VDD.t892 4.36035
R2145 VDD VDD.t1259 4.36035
R2146 VDD VDD.t1796 4.36035
R2147 VDD VDD.t706 4.36035
R2148 VDD VDD.t292 4.36035
R2149 VDD VDD.t1852 4.36035
R2150 VDD VDD.t1822 4.36035
R2151 VDD VDD.t240 4.36035
R2152 VDD VDD.t1265 4.36035
R2153 VDD VDD.t1801 4.36035
R2154 VDD VDD.t5 4.36035
R2155 VDD VDD.t877 4.36035
R2156 VDD VDD.t288 4.36035
R2157 VDD VDD.t152 4.36035
R2158 VDD VDD.t1891 4.36035
R2159 VDD VDD.t893 4.36035
R2160 VDD VDD.t320 4.36035
R2161 VDD VDD.t1890 4.36035
R2162 VDD VDD.t704 4.36035
R2163 VDD VDD.t1895 4.36035
R2164 VDD VDD.t273 4.36035
R2165 VDD VDD.t45 4.36035
R2166 VDD VDD.t1803 4.36035
R2167 VDD VDD.t1267 4.36035
R2168 VDD VDD.t1254 4.36035
R2169 VDD VDD.t416 4.36035
R2170 VDD VDD.t746 4.36035
R2171 VDD VDD.t258 4.36035
R2172 VDD VDD.t732 4.36035
R2173 VDD VDD.t742 4.36035
R2174 VDD VDD.t166 4.36035
R2175 VDD VDD.t757 4.36035
R2176 VDD VDD.t631 4.36035
R2177 VDD VDD.t2022 4.36035
R2178 VDD VDD.t374 4.36035
R2179 VDD VDD.t1550 4.36035
R2180 VDD VDD.t1032 4.36035
R2181 VDD VDD.t783 4.36035
R2182 VDD VDD.t505 4.36035
R2183 VDD VDD.t1180 4.36035
R2184 VDD VDD.t517 4.36035
R2185 VDD VDD.t2102 4.36035
R2186 VDD VDD.t499 4.36035
R2187 VDD VDD.t1549 4.36035
R2188 VDD VDD.t2004 4.36035
R2189 VDD VDD.t1950 4.36035
R2190 VDD VDD.t1914 4.36035
R2191 VDD VDD.t935 4.36035
R2192 VDD VDD.t1484 4.36035
R2193 VDD VDD.t1190 4.36035
R2194 VDD VDD.t1223 4.36035
R2195 VDD VDD.t515 4.36035
R2196 VDD VDD.t324 4.36035
R2197 VDD VDD.t1998 4.36035
R2198 VDD VDD.t2021 4.36035
R2199 VDD VDD.t2028 4.36035
R2200 VDD VDD.t1192 4.36035
R2201 VDD VDD.t785 4.36035
R2202 VDD VDD.t501 4.36035
R2203 VDD VDD.t1182 4.36035
R2204 VDD VDD.t1939 4.36035
R2205 VDD VDD.t602 4.36035
R2206 VDD VDD.t1122 4.36035
R2207 VDD VDD.t852 4.36035
R2208 VDD VDD.t491 4.36035
R2209 VDD VDD.t728 4.36035
R2210 VDD VDD.t158 4.36035
R2211 VDD VDD.t360 4.36035
R2212 VDD VDD.t890 4.36035
R2213 VDD VDD.t3 4.36035
R2214 VDD VDD.t185 4.36035
R2215 VDD VDD.t885 4.36035
R2216 VDD VDD.t1805 4.36035
R2217 VDD VDD.t294 4.36035
R2218 VDD VDD.t296 4.36035
R2219 VDD VDD.t493 4.36035
R2220 VDD VDD.t271 4.36035
R2221 VDD VDD.t187 4.36035
R2222 VDD VDD.t203 4.36035
R2223 VDD VDD.t1944 4.36035
R2224 VDD VDD.t867 4.36035
R2225 VDD VDD.t169 4.36035
R2226 VDD VDD.t51 4.36035
R2227 VDD VDD.t750 4.36035
R2228 VDD VDD.t336 4.36035
R2229 VDD VDD.t1238 4.36035
R2230 VDD VDD.t89 4.36035
R2231 VDD VDD.t1240 4.36035
R2232 VDD VDD.t1727 4.36035
R2233 VDD VDD.t120 4.36035
R2234 VDD VDD.t2069 4.36035
R2235 VDD VDD.t1749 4.36035
R2236 VDD VDD.t201 4.36035
R2237 VDD VDD.t181 4.36035
R2238 VDD VDD.t1729 4.36035
R2239 VDD VDD.t368 4.36035
R2240 VDD VDD.t1753 4.36035
R2241 VDD VDD.t1826 4.36035
R2242 VDD VDD.t43 4.36035
R2243 VDD VDD.t1237 4.36035
R2244 VDD VDD.t175 4.36035
R2245 VDD VDD.t1725 4.36035
R2246 VDD VDD.t1777 4.36035
R2247 VDD VDD.t47 4.36035
R2248 VDD VDD.t117 4.36035
R2249 VDD VDD.t1959 4.36035
R2250 VDD VDD.t148 4.36035
R2251 VDD VDD.t81 4.36035
R2252 VDD VDD.t177 4.36035
R2253 VDD VDD.t1903 4.36035
R2254 VDD VDD.t1824 4.36035
R2255 VDD VDD.t41 4.36035
R2256 VDD VDD.t756 4.36035
R2257 VDD VDD.t1952 4.36035
R2258 VDD VDD.t1723 4.36035
R2259 VDD VDD.t150 4.36035
R2260 VDD VDD.t2006 4.36035
R2261 VDD VDD.t1130 4.36035
R2262 VDD VDD.t1946 4.36035
R2263 VDD VDD.t132 4.36035
R2264 VDD VDD.t1242 4.36035
R2265 VDD VDD.t171 4.36035
R2266 VDD VDD.t1907 4.36035
R2267 VDD VDD.t1757 4.36035
R2268 VDD VDD.t1948 4.36035
R2269 VDD VDD.t2019 4.36035
R2270 VDD VDD.t118 4.36035
R2271 VDD VDD.t1912 4.36035
R2272 VDD VDD.t1206 4.36035
R2273 VDD VDD.t872 4.36035
R2274 VDD VDD.t863 4.36035
R2275 VDD VDD.t1784 4.36035
R2276 VDD VDD.t1090 4.36035
R2277 VDD VDD.t1751 4.36035
R2278 VDD VDD.t53 4.36035
R2279 VDD VDD.t59 4.36035
R2280 VDD VDD.t1747 4.36035
R2281 VDD VDD.t378 4.36035
R2282 VDD VDD.t1927 4.36035
R2283 VDD VDD.t328 4.36035
R2284 VDD VDD.t795 4.36035
R2285 VDD VDD.t1731 4.36035
R2286 VDD VDD.t1956 4.36035
R2287 VDD VDD.t1745 4.36035
R2288 VDD VDD.t1773 4.36035
R2289 VDD VDD.t1771 4.36035
R2290 VDD VDD.t1832 4.36035
R2291 VDD VDD.t1830 4.36035
R2292 VDD VDD.t2015 4.36035
R2293 VDD VDD.t2013 4.36035
R2294 VDD VDD.t65 4.36035
R2295 VDD VDD.t63 4.36035
R2296 VDD VDD.t858 4.36035
R2297 VDD VDD.t856 4.36035
R2298 VDD VDD.t2011 4.36035
R2299 VDD VDD.t2009 4.36035
R2300 VDD VDD.t862 4.36035
R2301 VDD VDD.t860 4.36035
R2302 VDD VDD.t2104 4.36035
R2303 VDD VDD.t1996 4.36035
R2304 VDD VDD.t1994 4.36035
R2305 VDD VDD.t1140 4.36035
R2306 VDD VDD.t1138 4.36035
R2307 VDD VDD.t1088 4.36035
R2308 VDD VDD.t1086 4.36035
R2309 VDD VDD.t384 4.36035
R2310 VDD VDD.t382 4.36035
R2311 VDD VDD.t2002 4.36035
R2312 VDD VDD.t2000 4.36035
R2313 VDD VDD.t128 4.36035
R2314 VDD VDD.t126 4.36035
R2315 VDD VDD.t1789 4.36035
R2316 VDD VDD.t1785 4.36035
R2317 VDD VDD.t1741 4.36035
R2318 VDD VDD.t1739 4.36035
R2319 VDD VDD.t1737 4.36035
R2320 VDD VDD.t1735 4.36035
R2321 VDD VDD.t1733 4.36035
R2322 VDD VDD.t1732 4.36035
R2323 VDD VDD.t634 4.36035
R2324 VDD VDD.t633 4.36035
R2325 VDD VDD.t644 4.36035
R2326 VDD VDD.t642 4.36035
R2327 VDD VDD.t606 4.36035
R2328 VDD VDD.t604 4.36035
R2329 VDD VDD.t1396 4.36035
R2330 VDD VDD.t1394 4.36035
R2331 VDD VDD.t1227 4.36035
R2332 VDD VDD.t1225 4.36035
R2333 VDD VDD.t1142 4.36035
R2334 VDD VDD.t1034 4.36035
R2335 VDD VDD.t789 4.36035
R2336 VDD VDD.t1899 4.36035
R2337 VDD VDD.t2094 4.36035
R2338 VDD VDD.t1933 4.36035
R2339 VDD VDD.t2024 4.36035
R2340 VDD VDD.t35 4.36035
R2341 VDD VDD.t2060 4.36035
R2342 VDD VDD.t2096 4.36035
R2343 VDD VDD.t338 4.36035
R2344 VDD VDD.t205 4.36035
R2345 VDD VDD.t199 4.36035
R2346 VDD VDD.t2098 4.36035
R2347 VDD VDD.t2100 4.36035
R2348 VDD VDD.t869 4.36035
R2349 VDD VDD.t1792 4.36035
R2350 VDD VDD.t1755 4.36035
R2351 VDD VDD.t1246 4.36035
R2352 VDD VDD.t99 4.36035
R2353 VDD VDD.t193 4.36035
R2354 VDD VDD.t2058 4.36035
R2355 VDD VDD.t1794 4.36035
R2356 VDD VDD.t791 4.36035
R2357 VDD VDD.t61 4.36035
R2358 VDD VDD.t1931 4.36035
R2359 VDD VDD.t267 4.36035
R2360 VDD VDD.t793 4.36035
R2361 VDD VDD.t49 4.36035
R2362 VDD VDD.t348 4.36035
R2363 VDD VDD.t813 4.36035
R2364 VDD VDD.t811 4.36035
R2365 VDD VDD.t1325 4.36035
R2366 VDD VDD.t1324 4.36035
R2367 VDD VDD.t1323 4.36035
R2368 VDD VDD.t1659 4.36035
R2369 VDD VDD.t1658 4.36035
R2370 VDD VDD.t1657 4.36035
R2371 VDD VDD.t1560 4.36035
R2372 VDD VDD.t1558 4.36035
R2373 VDD VDD.t1556 4.36035
R2374 VDD VDD.t691 4.36035
R2375 VDD VDD.t689 4.36035
R2376 VDD VDD.t687 4.36035
R2377 VDD VDD.t915 4.36035
R2378 VDD VDD.t913 4.36035
R2379 VDD VDD.t911 4.36035
R2380 VDD VDD.t1432 4.36035
R2381 VDD VDD.t1430 4.36035
R2382 VDD VDD.t1428 4.36035
R2383 VDD VDD.t586 4.36035
R2384 VDD VDD.t584 4.36035
R2385 VDD VDD.t582 4.36035
R2386 VDD VDD.t981 4.36035
R2387 VDD VDD.t980 4.36035
R2388 VDD VDD.t978 4.36035
R2389 VDD VDD.t1178 4.36035
R2390 VDD VDD.t1176 4.36035
R2391 VDD VDD.t1174 4.36035
R2392 VDD VDD.t1547 4.36035
R2393 VDD VDD.t1545 4.36035
R2394 VDD VDD.t1543 4.36035
R2395 VDD VDD.t905 4.36035
R2396 VDD VDD.t903 4.36035
R2397 VDD VDD.t281 4.36035
R2398 VDD VDD.t279 4.36035
R2399 VDD VDD.t277 4.36035
R2400 VDD VDD.t544 4.36035
R2401 VDD VDD.t542 4.36035
R2402 VDD VDD.t540 4.36035
R2403 VDD VDD.t839 4.36035
R2404 VDD VDD.t837 4.36035
R2405 VDD VDD.t835 4.36035
R2406 VDD VDD.t1476 4.36035
R2407 VDD VDD.t1474 4.36035
R2408 VDD VDD.t1457 4.36035
R2409 VDD VDD.t1676 4.36035
R2410 VDD VDD.t1675 4.36035
R2411 VDD VDD.t1674 4.36035
R2412 VDD VDD.t1047 4.36035
R2413 VDD VDD.t1046 4.36035
R2414 VDD VDD.t1045 4.36035
R2415 VDD VDD.t2065 4.36035
R2416 VDD VDD.t2064 4.36035
R2417 VDD VDD.t2062 4.36035
R2418 VDD VDD.t396 4.36035
R2419 VDD VDD.t394 4.36035
R2420 VDD VDD.t392 4.36035
R2421 VDD VDD.t513 4.36035
R2422 VDD VDD.t511 4.36035
R2423 VDD VDD.t1590 4.36035
R2424 VDD VDD.t1291 4.36035
R2425 VDD VDD.t1290 4.36035
R2426 VDD VDD.t1288 4.36035
R2427 VDD VDD.t919 4.36035
R2428 VDD VDD.t917 4.36035
R2429 VDD VDD.t1315 4.36035
R2430 VDD VDD.t1313 4.36035
R2431 VDD VDD.t1311 4.36035
R2432 VDD VDD.t550 4.36035
R2433 VDD VDD.t548 4.36035
R2434 VDD VDD.t546 4.36035
R2435 VDD VDD.t1859 4.36035
R2436 VDD VDD.t1857 4.36035
R2437 VDD VDD.t1855 4.36035
R2438 VDD VDD.t1622 4.36035
R2439 VDD VDD.t1620 4.36035
R2440 VDD VDD.t1552 4.36035
R2441 VDD VDD.t1551 4.36035
R2442 VDD VDD.t1515 4.36035
R2443 VDD VDD.t1514 4.36035
R2444 VDD VDD.t1512 4.36035
R2445 VDD VDD.t1937 4.36035
R2446 VDD VDD.t1935 4.36035
R2447 VDD VDD.t1934 4.36035
R2448 VDD VDD.t1233 4.36035
R2449 VDD VDD.t1231 4.36035
R2450 VDD VDD.t1229 4.36035
R2451 VDD VDD.t1402 4.36035
R2452 VDD VDD.t1400 4.36035
R2453 VDD VDD.t1398 4.36035
R2454 VDD VDD.t1275 4.36035
R2455 VDD VDD.t1273 4.36035
R2456 VDD VDD.t1504 4.36035
R2457 VDD VDD.t685 4.36035
R2458 VDD VDD.t1465 4.36035
R2459 VDD VDD.t801 4.36035
R2460 VDD VDD.t799 4.36035
R2461 VDD VDD.t797 4.36035
R2462 VDD VDD.t1576 4.36035
R2463 VDD VDD.t1575 4.36035
R2464 VDD VDD.t825 4.36035
R2465 VDD VDD.t823 4.36035
R2466 VDD VDD.t821 4.36035
R2467 VDD VDD.t1479 4.36035
R2468 VDD VDD.t1478 4.36035
R2469 VDD VDD.t1477 4.36035
R2470 VDD VDD.t576 4.36035
R2471 VDD VDD.t574 4.36035
R2472 VDD VDD.t572 4.36035
R2473 VDD VDD.t1342 4.36035
R2474 VDD VDD.t1340 4.36035
R2475 VDD VDD.t1338 4.36035
R2476 VDD VDD.t354 4.36035
R2477 VDD VDD.t352 4.36035
R2478 VDD VDD.t350 4.36035
R2479 VDD VDD.t483 4.36035
R2480 VDD VDD.t481 4.36035
R2481 VDD VDD.t479 4.36035
R2482 VDD VDD.t696 4.36035
R2483 VDD VDD.t693 4.36035
R2484 VDD VDD.t422 4.36035
R2485 VDD VDD.t420 4.36035
R2486 VDD VDD.t418 4.36035
R2487 VDD VDD.t344 4.36035
R2488 VDD VDD.t477 4.36035
R2489 VDD VDD.t475 4.36035
R2490 VDD VDD.t473 4.36035
R2491 VDD VDD.t1414 4.36035
R2492 VDD VDD.t1412 4.36035
R2493 VDD VDD.t1410 4.36035
R2494 VDD VDD.t624 4.36035
R2495 VDD VDD.t622 4.36035
R2496 VDD VDD.t620 4.36035
R2497 VDD VDD.t1463 4.36035
R2498 VDD VDD.t1717 4.36035
R2499 VDD VDD.t1715 4.36035
R2500 VDD VDD.t1713 4.36035
R2501 VDD VDD.t1468 4.36035
R2502 VDD VDD.t1467 4.36035
R2503 VDD VDD.t1466 4.36035
R2504 VDD VDD.t683 4.36035
R2505 VDD VDD.t681 4.36035
R2506 VDD VDD.t679 4.36035
R2507 VDD VDD.t1078 4.36035
R2508 VDD VDD.t1076 4.36035
R2509 VDD VDD.t1074 4.36035
R2510 VDD VDD.t1360 4.36035
R2511 VDD VDD.t1358 4.36035
R2512 VDD VDD.t1356 4.36035
R2513 VDD VDD.t1094 4.36035
R2514 VDD VDD.t1092 4.36035
R2515 VDD VDD.t1321 4.36035
R2516 VDD VDD.t1319 4.36035
R2517 VDD VDD.t1317 4.36035
R2518 VDD VDD.t1056 4.36035
R2519 VDD VDD.t1574 4.36035
R2520 VDD VDD.t1640 4.36035
R2521 VDD VDD.t1638 4.36035
R2522 VDD VDD.t1636 4.36035
R2523 VDD VDD.t220 4.36035
R2524 VDD VDD.t1628 4.36035
R2525 VDD VDD.t1626 4.36035
R2526 VDD VDD.t1624 4.36035
R2527 VDD VDD.t769 4.36035
R2528 VDD VDD.t767 4.36035
R2529 VDD VDD.t765 4.36035
R2530 VDD VDD.t1084 4.36035
R2531 VDD VDD.t1082 4.36035
R2532 VDD VDD.t1080 4.36035
R2533 VDD VDD.t398 4.36035
R2534 VDD VDD.t1108 4.36035
R2535 VDD VDD.t1386 4.36035
R2536 VDD VDD.t1385 4.36035
R2537 VDD VDD.t1384 4.36035
R2538 VDD VDD.t1471 4.36035
R2539 VDD VDD.t1470 4.36035
R2540 VDD VDD.t1469 4.36035
R2541 VDD VDD.t432 4.36035
R2542 VDD VDD.t430 4.36035
R2543 VDD VDD.t428 4.36035
R2544 VDD VDD.t976 4.36035
R2545 VDD VDD.t974 4.36035
R2546 VDD VDD.t972 4.36035
R2547 VDD VDD.t845 4.36035
R2548 VDD VDD.t843 4.36035
R2549 VDD VDD.t841 4.36035
R2550 VDD VDD.t426 4.36035
R2551 VDD VDD.t1336 4.36035
R2552 VDD VDD.t1334 4.36035
R2553 VDD VDD.t1332 4.36035
R2554 VDD VDD.t1106 4.36035
R2555 VDD VDD.t1104 4.36035
R2556 VDD VDD.t1102 4.36035
R2557 VDD VDD.t1456 4.36035
R2558 VDD VDD.t1454 4.36035
R2559 VDD VDD.t1452 4.36035
R2560 VDD VDD.t570 4.36035
R2561 VDD VDD.t1377 4.36035
R2562 VDD VDD.t1375 4.36035
R2563 VDD VDD.t1373 4.36035
R2564 VDD VDD.t1348 4.36035
R2565 VDD VDD.t1346 4.36035
R2566 VDD VDD.t1344 4.36035
R2567 VDD VDD.t1330 4.36035
R2568 VDD VDD.t1328 4.36035
R2569 VDD VDD.n10 4.35925
R2570 VDD VDD.n87 4.35925
R2571 VDD VDD.n1556 4.35925
R2572 VDD VDD.n1428 4.35925
R2573 VDD VDD.n1370 4.35925
R2574 VDD VDD.n1305 4.35925
R2575 VDD VDD.n1241 4.35925
R2576 VDD VDD.n113 4.35925
R2577 VDD VDD.n244 4.35925
R2578 VDD VDD.n183 4.35925
R2579 VDD VDD.n1184 4.35925
R2580 VDD VDD.n312 4.35925
R2581 VDD VDD.n419 4.35925
R2582 VDD VDD.n340 4.35925
R2583 VDD VDD.n504 4.35925
R2584 VDD VDD.n566 4.35925
R2585 VDD VDD.n644 4.35925
R2586 VDD VDD.n1098 4.35925
R2587 VDD VDD.n670 4.35925
R2588 VDD VDD.n746 4.35925
R2589 VDD VDD.n819 4.35925
R2590 VDD VDD.n879 4.35925
R2591 VDD VDD.n1499 4.35923
R2592 VDD VDD.t725 4.35923
R2593 VDD VDD.t1808 4.35923
R2594 VDD VDD.t355 4.35923
R2595 VDD VDD.t1127 4.35923
R2596 VDD VDD.t1900 4.35923
R2597 VDD VDD.t1904 4.35923
R2598 VDD VDD.t1827 4.35923
R2599 VDD VDD.t313 4.35923
R2600 VDD VDD.t1353 4.35923
R2601 VDD VDD.t1613 4.35923
R2602 VDD VDD.t1306 4.35923
R2603 VDD VDD.n476 4.35923
R2604 VDD VDD.n542 4.35923
R2605 VDD VDD.n622 4.35923
R2606 VDD VDD.t2073 4.35923
R2607 VDD VDD.n689 4.35923
R2608 VDD VDD.t1433 4.35923
R2609 VDD VDD.t1633 4.35923
R2610 VDD VDD.n794 4.35923
R2611 VDD VDD.n67 4.35913
R2612 VDD VDD.n395 4.35913
R2613 VDD VDD.t1019 4.34469
R2614 VDD VDD.t1040 4.34469
R2615 VDD VDD.t1554 4.34469
R2616 VDD VDD.t968 4.34469
R2617 VDD VDD.t1586 4.34469
R2618 VDD VDD.t564 4.34469
R2619 VDD VDD.t608 4.34469
R2620 VDD.n76 VDD.t748 4.0923
R2621 VDD.n74 VDD.t734 4.0923
R2622 VDD.n73 VDD.t358 4.0923
R2623 VDD.n72 VDD.t1250 4.0923
R2624 VDD.n1491 VDD.t744 4.0923
R2625 VDD.n43 VDD.t1263 4.0923
R2626 VDD.n44 VDD.t287 4.0923
R2627 VDD.n45 VDD.t414 4.0923
R2628 VDD.n46 VDD.t11 4.0923
R2629 VDD.n47 VDD.t876 4.0923
R2630 VDD.n48 VDD.t1270 4.0923
R2631 VDD.n49 VDD.t1807 4.0923
R2632 VDD.n1507 VDD.t1248 4.0923
R2633 VDD.n1508 VDD.t333 4.0923
R2634 VDD.n1509 VDD.t720 4.0923
R2635 VDD.n1510 VDD.t1800 4.0923
R2636 VDD.n1511 VDD.t1816 4.0923
R2637 VDD.n1512 VDD.t331 4.0923
R2638 VDD.n1513 VDD.t17 4.0923
R2639 VDD.n1514 VDD.t488 4.0923
R2640 VDD.n9 VDD.t285 4.0923
R2641 VDD.n8 VDD.t1870 4.0923
R2642 VDD.n7 VDD.t329 4.0923
R2643 VDD.n6 VDD.t749 4.0923
R2644 VDD.n5 VDD.t230 4.0923
R2645 VDD.n4 VDD.t7 4.0923
R2646 VDD.n3 VDD.t711 4.0923
R2647 VDD.n2 VDD.t290 4.0923
R2648 VDD.n52 VDD.t154 4.0923
R2649 VDD.n53 VDD.t339 4.0923
R2650 VDD.n54 VDD.t713 4.0923
R2651 VDD.n55 VDD.t228 4.0923
R2652 VDD.n56 VDD.t241 4.0923
R2653 VDD.n57 VDD.t388 4.0923
R2654 VDD.n58 VDD.t254 4.0923
R2655 VDD.n59 VDD.t1268 4.0923
R2656 VDD.n1427 VDD.t710 4.0923
R2657 VDD.n1426 VDD.t1990 4.0923
R2658 VDD.n1425 VDD.t300 4.0923
R2659 VDD.n1424 VDD.t1798 4.0923
R2660 VDD.n1439 VDD.t179 4.0923
R2661 VDD.n1440 VDD.t708 4.0923
R2662 VDD.n1415 VDD.t738 4.0923
R2663 VDD.n1416 VDD.t1888 4.0923
R2664 VDD.n1417 VDD.t736 4.0923
R2665 VDD.n1418 VDD.t164 4.0923
R2666 VDD.n1419 VDD.t162 4.0923
R2667 VDD.n1420 VDD.t1992 4.0923
R2668 VDD.n1421 VDD.t1809 4.0923
R2669 VDD.n1448 VDD.t1893 4.0923
R2670 VDD.n1449 VDD.t13 4.0923
R2671 VDD.n1450 VDD.t69 4.0923
R2672 VDD.n1451 VDD.t1256 4.0923
R2673 VDD.n1452 VDD.t189 4.0923
R2674 VDD.n1453 VDD.t895 4.0923
R2675 VDD.n1454 VDD.t1818 4.0923
R2676 VDD.n1455 VDD.t412 4.0923
R2677 VDD.n1462 VDD.t302 4.0923
R2678 VDD.n1463 VDD.t260 4.0923
R2679 VDD.n41 VDD.t722 4.0923
R2680 VDD.n40 VDD.t888 4.0923
R2681 VDD.n39 VDD.t1252 4.0923
R2682 VDD.n38 VDD.t362 4.0923
R2683 VDD.n37 VDD.t134 4.0923
R2684 VDD.n36 VDD.t1261 4.0923
R2685 VDD.n35 VDD.t726 4.0923
R2686 VDD.n34 VDD.t740 4.0923
R2687 VDD.n33 VDD.t71 4.0923
R2688 VDD.n32 VDD.t15 4.0923
R2689 VDD.n31 VDD.t883 4.0923
R2690 VDD.n30 VDD.t718 4.0923
R2691 VDD.n29 VDD.t1221 4.0923
R2692 VDD.n28 VDD.t9 4.0923
R2693 VDD.n27 VDD.t1820 4.0923
R2694 VDD.n24 VDD.t486 4.0923
R2695 VDD.n23 VDD.t247 4.0923
R2696 VDD.n22 VDD.t424 4.0923
R2697 VDD.n21 VDD.t484 4.0923
R2698 VDD.n20 VDD.t390 4.0923
R2699 VDD.n19 VDD.t249 4.0923
R2700 VDD.n18 VDD.t878 4.0923
R2701 VDD.n1550 VDD.t1257 4.0923
R2702 VDD.n1304 VDD.t2026 4.0923
R2703 VDD.n1303 VDD.t1188 4.0923
R2704 VDD.n1302 VDD.t698 4.0923
R2705 VDD.n1301 VDD.t1126 4.0923
R2706 VDD.n1316 VDD.t507 4.0923
R2707 VDD.n1317 VDD.t1941 4.0923
R2708 VDD.n1292 VDD.t702 4.0923
R2709 VDD.n1293 VDD.t781 4.0923
R2710 VDD.n1294 VDD.t238 4.0923
R2711 VDD.n1295 VDD.t1186 4.0923
R2712 VDD.n1296 VDD.t1184 4.0923
R2713 VDD.n1297 VDD.t265 4.0923
R2714 VDD.n1298 VDD.t1128 4.0923
R2715 VDD.n1325 VDD.t1911 4.0923
R2716 VDD.n1326 VDD.t262 4.0923
R2717 VDD.n1327 VDD.t1943 4.0923
R2718 VDD.n1328 VDD.t23 4.0923
R2719 VDD.n1329 VDD.t2067 4.0923
R2720 VDD.n1330 VDD.t19 4.0923
R2721 VDD.n1331 VDD.t1036 4.0923
R2722 VDD.n1332 VDD.t380 4.0923
R2723 VDD.n1334 VDD.t364 4.0923
R2724 VDD.n1335 VDD.t1918 4.0923
R2725 VDD.n1336 VDD.t700 4.0923
R2726 VDD.n1337 VDD.t464 4.0923
R2727 VDD.n1338 VDD.t1124 4.0923
R2728 VDD.n1339 VDD.t113 4.0923
R2729 VDD.n1340 VDD.t31 4.0923
R2730 VDD.n1341 VDD.t33 4.0923
R2731 VDD.n1342 VDD.t356 4.0923
R2732 VDD.n1348 VDD.t109 4.0923
R2733 VDD.n1349 VDD.t322 4.0923
R2734 VDD.n1350 VDD.t115 4.0923
R2735 VDD.n1351 VDD.t79 4.0923
R2736 VDD.n1352 VDD.t77 4.0923
R2737 VDD.n1353 VDD.t136 4.0923
R2738 VDD.n1354 VDD.t29 4.0923
R2739 VDD.n1355 VDD.t111 4.0923
R2740 VDD.n1364 VDD.t263 4.0923
R2741 VDD.n1363 VDD.t37 4.0923
R2742 VDD.n1362 VDD.t1781 4.0923
R2743 VDD.n1361 VDD.t105 4.0923
R2744 VDD.n1360 VDD.t1219 4.0923
R2745 VDD.n1359 VDD.t335 4.0923
R2746 VDD.n1358 VDD.t138 4.0923
R2747 VDD.n1357 VDD.t27 4.0923
R2748 VDD.n112 VDD.t168 4.0923
R2749 VDD.n111 VDD.t306 4.0923
R2750 VDD.n110 VDD.t57 4.0923
R2751 VDD.n109 VDD.t146 4.0923
R2752 VDD.n124 VDD.t1721 4.0923
R2753 VDD.n125 VDD.t91 4.0923
R2754 VDD.n100 VDD.t1761 4.0923
R2755 VDD.n101 VDD.t130 4.0923
R2756 VDD.n102 VDD.t1783 4.0923
R2757 VDD.n103 VDD.t97 4.0923
R2758 VDD.n104 VDD.t372 4.0923
R2759 VDD.n105 VDD.t39 4.0923
R2760 VDD.n106 VDD.t1905 4.0923
R2761 VDD.n133 VDD.t144 4.0923
R2762 VDD.n134 VDD.t308 4.0923
R2763 VDD.n135 VDD.t1897 4.0923
R2764 VDD.n136 VDD.t122 4.0923
R2765 VDD.n137 VDD.t95 4.0923
R2766 VDD.n138 VDD.t1775 4.0923
R2767 VDD.n139 VDD.t142 4.0923
R2768 VDD.n140 VDD.t326 4.0923
R2769 VDD.n142 VDD.t304 4.0923
R2770 VDD.n143 VDD.t85 4.0923
R2771 VDD.n144 VDD.t1961 4.0923
R2772 VDD.n1220 VDD.t366 4.0923
R2773 VDD.n1219 VDD.t83 4.0923
R2774 VDD.n1218 VDD.t1923 4.0923
R2775 VDD.n1217 VDD.t1244 4.0923
R2776 VDD.n1216 VDD.t370 4.0923
R2777 VDD.n1215 VDD.t1901 4.0923
R2778 VDD.n1209 VDD.t752 4.0923
R2779 VDD.n1208 VDD.t87 4.0923
R2780 VDD.n1207 VDD.t140 4.0923
R2781 VDD.n1206 VDD.t1763 4.0923
R2782 VDD.n1205 VDD.t787 4.0923
R2783 VDD.n1204 VDD.t75 4.0923
R2784 VDD.n1203 VDD.t503 4.0923
R2785 VDD.n1202 VDD.t25 4.0923
R2786 VDD.n1199 VDD.t1787 4.0923
R2787 VDD.n1198 VDD.t21 4.0923
R2788 VDD.n1197 VDD.t103 4.0923
R2789 VDD.n1196 VDD.t2007 4.0923
R2790 VDD.n1195 VDD.t346 4.0923
R2791 VDD.n1194 VDD.t73 4.0923
R2792 VDD.n1193 VDD.t107 4.0923
R2793 VDD.n1235 VDD.t1780 4.0923
R2794 VDD.n177 VDD.t1909 4.0923
R2795 VDD.n176 VDD.t985 4.0923
R2796 VDD.n175 VDD.t195 4.0923
R2797 VDD.n174 VDD.t1929 4.0923
R2798 VDD.n172 VDD.t2018 4.0923
R2799 VDD.n171 VDD.t874 4.0923
R2800 VDD.n170 VDD.t1743 4.0923
R2801 VDD.n169 VDD.t101 4.0923
R2802 VDD.n168 VDD.t1921 4.0923
R2803 VDD.n167 VDD.t191 4.0923
R2804 VDD.n166 VDD.t854 4.0923
R2805 VDD.n165 VDD.t1779 4.0923
R2806 VDD.n164 VDD.t314 4.0923
R2807 VDD.n163 VDD.t865 4.0923
R2808 VDD.n162 VDD.t93 4.0923
R2809 VDD.n161 VDD.t183 4.0923
R2810 VDD.n160 VDD.t1769 4.0923
R2811 VDD.n159 VDD.t871 4.0923
R2812 VDD.n158 VDD.t1925 4.0923
R2813 VDD.n157 VDD.t1954 4.0923
R2814 VDD.n156 VDD.t1038 4.0923
R2815 VDD.n213 VDD.t754 4.0923
R2816 VDD.n214 VDD.t1235 4.0923
R2817 VDD.n147 VDD.t1916 4.0923
R2818 VDD.n148 VDD.t1767 4.0923
R2819 VDD.n149 VDD.t1517 4.0923
R2820 VDD.n150 VDD.t67 4.0923
R2821 VDD.n151 VDD.t173 4.0923
R2822 VDD.n152 VDD.t1963 4.0923
R2823 VDD.n153 VDD.t1828 4.0923
R2824 VDD.n222 VDD.t376 4.0923
R2825 VDD.n223 VDD.t124 4.0923
R2826 VDD.n224 VDD.t55 4.0923
R2827 VDD.n225 VDD.t207 4.0923
R2828 VDD.n226 VDD.t197 4.0923
R2829 VDD.n227 VDD.t1765 4.0923
R2830 VDD.n228 VDD.t386 4.0923
R2831 VDD.n229 VDD.t983 4.0923
R2832 VDD.n238 VDD.t937 4.0923
R2833 VDD.n237 VDD.t1919 4.0923
R2834 VDD.n236 VDD.t2016 4.0923
R2835 VDD.n235 VDD.t1957 4.0923
R2836 VDD.n234 VDD.t1790 4.0923
R2837 VDD.n233 VDD.t269 4.0923
R2838 VDD.n232 VDD.t312 4.0923
R2839 VDD.n231 VDD.t310 4.0923
R2840 VDD.n306 VDD.t448 4.0923
R2841 VDD.n305 VDD.t450 4.0923
R2842 VDD.n304 VDD.t452 4.0923
R2843 VDD.n303 VDD.t534 4.0923
R2844 VDD.n301 VDD.t536 4.0923
R2845 VDD.n300 VDD.t538 4.0923
R2846 VDD.n299 VDD.t1684 4.0923
R2847 VDD.n298 VDD.t1686 4.0923
R2848 VDD.n297 VDD.t1688 4.0923
R2849 VDD.n296 VDD.t1168 4.0923
R2850 VDD.n295 VDD.t1170 4.0923
R2851 VDD.n294 VDD.t1172 4.0923
R2852 VDD.n293 VDD.t1614 4.0923
R2853 VDD.n286 VDD.t1616 4.0923
R2854 VDD.n285 VDD.t1618 4.0923
R2855 VDD.n284 VDD.t1608 4.0923
R2856 VDD.n283 VDD.t1610 4.0923
R2857 VDD.n282 VDD.t1612 4.0923
R2858 VDD.n281 VDD.t1301 4.0923
R2859 VDD.n280 VDD.t1303 4.0923
R2860 VDD.n279 VDD.t1305 4.0923
R2861 VDD.n276 VDD.t590 4.0923
R2862 VDD.n275 VDD.t592 4.0923
R2863 VDD.n274 VDD.t654 4.0923
R2864 VDD.n273 VDD.t656 4.0923
R2865 VDD.n272 VDD.t658 4.0923
R2866 VDD.n271 VDD.t1350 4.0923
R2867 VDD.n270 VDD.t1352 4.0923
R2868 VDD.n269 VDD.t1354 4.0923
R2869 VDD.n268 VDD.t1840 4.0923
R2870 VDD.n267 VDD.t1842 4.0923
R2871 VDD.n266 VDD.t1844 4.0923
R2872 VDD.n265 VDD.t897 4.0923
R2873 VDD.n264 VDD.t899 4.0923
R2874 VDD.n263 VDD.t901 4.0923
R2875 VDD.n262 VDD.t775 4.0923
R2876 VDD.n261 VDD.t777 4.0923
R2877 VDD.n258 VDD.t1472 4.0923
R2878 VDD.n257 VDD.t1166 4.0923
R2879 VDD.n256 VDD.t1165 4.0923
R2880 VDD.n255 VDD.t1163 4.0923
R2881 VDD.n254 VDD.t1528 4.0923
R2882 VDD.n253 VDD.t1527 4.0923
R2883 VDD.n252 VDD.t1525 4.0923
R2884 VDD.n1178 VDD.t779 4.0923
R2885 VDD.n277 VDD.t588 4.0923
R2886 VDD.n339 VDD.t1678 4.0923
R2887 VDD.n338 VDD.t1680 4.0923
R2888 VDD.n337 VDD.t1682 4.0923
R2889 VDD.n336 VDD.t636 4.0923
R2890 VDD.n351 VDD.t638 4.0923
R2891 VDD.n352 VDD.t640 4.0923
R2892 VDD.n327 VDD.t2030 4.0923
R2893 VDD.n328 VDD.t2032 4.0923
R2894 VDD.n329 VDD.t2034 4.0923
R2895 VDD.n330 VDD.t400 4.0923
R2896 VDD.n331 VDD.t402 4.0923
R2897 VDD.n332 VDD.t404 4.0923
R2898 VDD.n333 VDD.t1307 4.0923
R2899 VDD.n363 VDD.t1005 4.0923
R2900 VDD.n364 VDD.t1007 4.0923
R2901 VDD.n366 VDD.t1446 4.0923
R2902 VDD.n370 VDD.t1448 4.0923
R2903 VDD.n371 VDD.t1450 4.0923
R2904 VDD.n379 VDD.t945 4.0923
R2905 VDD.n381 VDD.t947 4.0923
R2906 VDD.n382 VDD.t1416 4.0923
R2907 VDD.n383 VDD.t1418 4.0923
R2908 VDD.n396 VDD.t991 4.0923
R2909 VDD.n398 VDD.t993 4.0923
R2910 VDD.n399 VDD.t995 4.0923
R2911 VDD.n400 VDD.t1661 4.0923
R2912 VDD.n401 VDD.t1663 4.0923
R2913 VDD.n402 VDD.t1665 4.0923
R2914 VDD.n403 VDD.t1404 4.0923
R2915 VDD.n404 VDD.t1406 4.0923
R2916 VDD.n413 VDD.t960 4.0923
R2917 VDD.n412 VDD.t562 4.0923
R2918 VDD.n411 VDD.t560 4.0923
R2919 VDD.n410 VDD.t558 4.0923
R2920 VDD.n409 VDD.t630 4.0923
R2921 VDD.n408 VDD.t628 4.0923
R2922 VDD.n407 VDD.t626 4.0923
R2923 VDD.n406 VDD.t1408 4.0923
R2924 VDD.n367 VDD.t444 4.0923
R2925 VDD.n362 VDD.t1003 4.0923
R2926 VDD.n361 VDD.t1309 4.0923
R2927 VDD.n360 VDD.t1308 4.0923
R2928 VDD.n495 VDD.t848 4.0923
R2929 VDD.n493 VDD.t850 4.0923
R2930 VDD.n491 VDD.t997 4.0923
R2931 VDD.n488 VDD.t999 4.0923
R2932 VDD.n486 VDD.t1001 4.0923
R2933 VDD.n484 VDD.t1062 4.0923
R2934 VDD.n483 VDD.t1064 4.0923
R2935 VDD.n481 VDD.t1066 4.0923
R2936 VDD.n480 VDD.t1023 4.0923
R2937 VDD.n479 VDD.t1025 4.0923
R2938 VDD.n478 VDD.t1027 4.0923
R2939 VDD.n477 VDD.t1132 4.0923
R2940 VDD.n463 VDD.t1297 4.0923
R2941 VDD.n461 VDD.t1878 4.0923
R2942 VDD.n450 VDD.t2088 4.0923
R2943 VDD.n546 VDD.t1671 4.0923
R2944 VDD.n547 VDD.t1673 4.0923
R2945 VDD.n548 VDD.t1834 4.0923
R2946 VDD.n549 VDD.t1836 4.0923
R2947 VDD.n550 VDD.t1838 4.0923
R2948 VDD.n551 VDD.t660 4.0923
R2949 VDD.n560 VDD.t1212 4.0923
R2950 VDD.n559 VDD.t1210 4.0923
R2951 VDD.n558 VDD.t1208 4.0923
R2952 VDD.n557 VDD.t2072 4.0923
R2953 VDD.n556 VDD.t2071 4.0923
R2954 VDD.n555 VDD.t2070 4.0923
R2955 VDD.n554 VDD.t664 4.0923
R2956 VDD.n553 VDD.t662 4.0923
R2957 VDD.n447 VDD.t1508 4.0923
R2958 VDD.n492 VDD.t952 4.0923
R2959 VDD.n637 VDD.t234 4.0923
R2960 VDD.n628 VDD.t1570 4.0923
R2961 VDD.n604 VDD.t2038 4.0923
R2962 VDD.n602 VDD.t2042 4.0923
R2963 VDD.n599 VDD.t926 4.0923
R2964 VDD.n591 VDD.t2074 4.0923
R2965 VDD.n590 VDD.t2076 4.0923
R2966 VDD.n589 VDD.t2078 4.0923
R2967 VDD.n588 VDD.t1496 4.0923
R2968 VDD.n587 VDD.t1498 4.0923
R2969 VDD.n586 VDD.t1500 4.0923
R2970 VDD.n585 VDD.t1440 4.0923
R2971 VDD.n584 VDD.t1442 4.0923
R2972 VDD.n583 VDD.t1444 4.0923
R2973 VDD.n580 VDD.t1461 4.0923
R2974 VDD.n579 VDD.t1459 4.0923
R2975 VDD.n578 VDD.t922 4.0923
R2976 VDD.n577 VDD.t921 4.0923
R2977 VDD.n576 VDD.t920 4.0923
R2978 VDD.n575 VDD.t600 4.0923
R2979 VDD.n574 VDD.t598 4.0923
R2980 VDD.n1092 VDD.t596 4.0923
R2981 VDD.n623 VDD.t616 4.0923
R2982 VDD.n624 VDD.t615 4.0923
R2983 VDD.n625 VDD.t1482 4.0923
R2984 VDD.n626 VDD.t1481 4.0923
R2985 VDD.n627 VDD.t1480 4.0923
R2986 VDD.n669 VDD.t1044 4.0923
R2987 VDD.n668 VDD.t1422 4.0923
R2988 VDD.n667 VDD.t1424 4.0923
R2989 VDD.n666 VDD.t1426 4.0923
R2990 VDD.n681 VDD.t222 4.0923
R2991 VDD.n656 VDD.t224 4.0923
R2992 VDD.n658 VDD.t226 4.0923
R2993 VDD.n659 VDD.t519 4.0923
R2994 VDD.n660 VDD.t521 4.0923
R2995 VDD.n661 VDD.t523 4.0923
R2996 VDD.n663 VDD.t454 4.0923
R2997 VDD.n699 VDD.t1988 4.0923
R2998 VDD.n702 VDD.t467 4.0923
R2999 VDD.n705 VDD.t469 4.0923
R3000 VDD.n706 VDD.t471 4.0923
R3001 VDD.n707 VDD.t1194 4.0923
R3002 VDD.n709 VDD.t1196 4.0923
R3003 VDD.n710 VDD.t1198 4.0923
R3004 VDD.n711 VDD.t1379 4.0923
R3005 VDD.n712 VDD.t1381 4.0923
R3006 VDD.n713 VDD.t1383 4.0923
R3007 VDD.n714 VDD.t1434 4.0923
R3008 VDD.n724 VDD.t1436 4.0923
R3009 VDD.n725 VDD.t1438 4.0923
R3010 VDD.n726 VDD.t1116 4.0923
R3011 VDD.n727 VDD.t1118 4.0923
R3012 VDD.n728 VDD.t1120 4.0923
R3013 VDD.n729 VDD.t1690 4.0923
R3014 VDD.n730 VDD.t1692 4.0923
R3015 VDD.n731 VDD.t1694 4.0923
R3016 VDD.n740 VDD.t1848 4.0923
R3017 VDD.n739 VDD.t1847 4.0923
R3018 VDD.n738 VDD.t966 4.0923
R3019 VDD.n737 VDD.t964 4.0923
R3020 VDD.n736 VDD.t962 4.0923
R3021 VDD.n735 VDD.t1031 4.0923
R3022 VDD.n734 VDD.t1029 4.0923
R3023 VDD.n733 VDD.t1028 4.0923
R3024 VDD.n698 VDD.t1486 4.0923
R3025 VDD.n812 VDD.t2056 4.0923
R3026 VDD.n811 VDD.t1200 4.0923
R3027 VDD.n810 VDD.t1202 4.0923
R3028 VDD.n809 VDD.t1204 4.0923
R3029 VDD.n807 VDD.t1598 4.0923
R3030 VDD.n806 VDD.t1600 4.0923
R3031 VDD.n804 VDD.t1604 4.0923
R3032 VDD.n790 VDD.t1110 4.0923
R3033 VDD.n789 VDD.t1112 4.0923
R3034 VDD.n788 VDD.t1114 4.0923
R3035 VDD.n787 VDD.t1388 4.0923
R3036 VDD.n786 VDD.t1390 4.0923
R3037 VDD.n785 VDD.t1392 4.0923
R3038 VDD.n784 VDD.t759 4.0923
R3039 VDD.n775 VDD.t2044 4.0923
R3040 VDD.n776 VDD.t2046 4.0923
R3041 VDD.n777 VDD.t2048 4.0923
R3042 VDD.n778 VDD.t1630 4.0923
R3043 VDD.n779 VDD.t1632 4.0923
R3044 VDD.n780 VDD.t1634 4.0923
R3045 VDD.n857 VDD.t829 4.0923
R3046 VDD.n858 VDD.t831 4.0923
R3047 VDD.n859 VDD.t833 4.0923
R3048 VDD.n860 VDD.t552 4.0923
R3049 VDD.n861 VDD.t554 4.0923
R3050 VDD.n862 VDD.t556 4.0923
R3051 VDD.n863 VDD.t1144 4.0923
R3052 VDD.n864 VDD.t1146 4.0923
R3053 VDD.n873 VDD.t1326 4.0923
R3054 VDD.n872 VDD.t1218 4.0923
R3055 VDD.n871 VDD.t1216 4.0923
R3056 VDD.n870 VDD.t1214 4.0923
R3057 VDD.n869 VDD.t819 4.0923
R3058 VDD.n868 VDD.t817 4.0923
R3059 VDD.n867 VDD.t815 4.0923
R3060 VDD.n866 VDD.t1147 4.0923
R3061 VDD.n930 VDD.t1978 4.0923
R3062 VDD.n929 VDD.t1980 4.0923
R3063 VDD.n928 VDD.t1982 4.0923
R3064 VDD.n927 VDD.t673 4.0923
R3065 VDD.n926 VDD.t675 4.0923
R3066 VDD.n924 VDD.t677 4.0923
R3067 VDD.n923 VDD.t1537 4.0923
R3068 VDD.n922 VDD.t1539 4.0923
R3069 VDD.n919 VDD.t2050 4.0923
R3070 VDD.n918 VDD.t2052 4.0923
R3071 VDD.n917 VDD.t2054 4.0923
R3072 VDD.n915 VDD.t648 4.0923
R3073 VDD.n914 VDD.t650 4.0923
R3074 VDD.n913 VDD.t652 4.0923
R3075 VDD.n912 VDD.t406 4.0923
R3076 VDD.n911 VDD.t408 4.0923
R3077 VDD.n910 VDD.t410 4.0923
R3078 VDD.n909 VDD.t1865 4.0923
R3079 VDD.n908 VDD.t1867 4.0923
R3080 VDD.n973 VDD.t1869 4.0923
R3081 VDD.n991 VDD.t1872 4.0923
R3082 VDD.n990 VDD.t1874 4.0923
R3083 VDD.n989 VDD.t1876 4.0923
R3084 VDD.n988 VDD.t1009 4.0923
R3085 VDD.n987 VDD.t1011 4.0923
R3086 VDD.n986 VDD.t1013 4.0923
R3087 VDD.n903 VDD.t214 4.0923
R3088 VDD.n902 VDD.t216 4.0923
R3089 VDD.n901 VDD.t218 4.0923
R3090 VDD.n900 VDD.t1096 4.0923
R3091 VDD.n899 VDD.t1098 4.0923
R3092 VDD.n898 VDD.t1100 4.0923
R3093 VDD.n897 VDD.t1652 4.0923
R3094 VDD.n886 VDD.t1654 4.0923
R3095 VDD.n888 VDD.t1656 4.0923
R3096 VDD.n889 VDD.t1519 4.0923
R3097 VDD.n890 VDD.t1521 4.0923
R3098 VDD.n891 VDD.t1523 4.0923
R3099 VDD.n892 VDD.t771 4.0923
R3100 VDD.n893 VDD.t773 4.0923
R3101 VDD.n374 VDD.t943 3.15624
R3102 VDD.n384 VDD.t1596 3.15624
R3103 VDD.n532 VDD.t2084 3.15624
R3104 VDD.n454 VDD.t1886 3.15624
R3105 VDD.n467 VDD.t1642 3.15624
R3106 VDD.n635 VDD.t1566 3.15624
R3107 VDD.n774 VDD.t1157 3.15624
R3108 VDD.n783 VDD.t1155 3.15624
R3109 VDD.n796 VDD.t1704 3.15624
R3110 VDD.n803 VDD.t1702 3.15624
R3111 VDD.n15 VDD.n14 2.96571
R3112 VDD.n92 VDD.n91 2.96571
R3113 VDD.n1561 VDD.n1560 2.96571
R3114 VDD.n1433 VDD.n1432 2.96571
R3115 VDD.n1375 VDD.n1374 2.96571
R3116 VDD.n1310 VDD.n1309 2.96571
R3117 VDD.n1246 VDD.n1245 2.96571
R3118 VDD.n118 VDD.n117 2.96571
R3119 VDD.n249 VDD.n248 2.96571
R3120 VDD.n188 VDD.n187 2.96571
R3121 VDD.n1189 VDD.n1188 2.96571
R3122 VDD.n317 VDD.n316 2.96571
R3123 VDD.n424 VDD.n423 2.96571
R3124 VDD.n345 VDD.n344 2.96571
R3125 VDD.n509 VDD.n508 2.96571
R3126 VDD.n571 VDD.n570 2.96571
R3127 VDD.n649 VDD.n648 2.96571
R3128 VDD.n1103 VDD.n1102 2.96571
R3129 VDD.n675 VDD.n674 2.96571
R3130 VDD.n751 VDD.n750 2.96571
R3131 VDD.n824 VDD.n823 2.96571
R3132 VDD.n884 VDD.n883 2.96571
R3133 VDD.n934 VDD.n932 2.96571
R3134 VDD.n1016 VDD.n1015 2.96571
R3135 VDD.n1571 VDD.n1 2.801
R3136 VDD.n1505 VDD.n1501 2.801
R3137 VDD.n1497 VDD.n51 2.801
R3138 VDD.n65 VDD.n64 2.801
R3139 VDD.n85 VDD.n84 2.801
R3140 VDD.n1423 VDD.n1422 2.801
R3141 VDD.n26 VDD.n25 2.801
R3142 VDD.n1460 VDD.n1457 2.801
R3143 VDD.n1300 VDD.n1299 2.801
R3144 VDD.n1366 VDD.n1365 2.801
R3145 VDD.n1344 VDD.n1343 2.801
R3146 VDD.n108 VDD.n107 2.801
R3147 VDD.n1201 VDD.n1200 2.801
R3148 VDD.n1211 VDD.n1210 2.801
R3149 VDD.n181 VDD.n178 2.801
R3150 VDD.n240 VDD.n239 2.801
R3151 VDD.n155 VDD.n154 2.801
R3152 VDD.n310 VDD.n307 2.801
R3153 VDD.n260 VDD.n259 2.801
R3154 VDD.n291 VDD.n290 2.801
R3155 VDD.n415 VDD.n414 2.801
R3156 VDD.n392 VDD.n391 2.801
R3157 VDD.n335 VDD.n334 2.801
R3158 VDD.n501 VDD.n496 2.801
R3159 VDD.n539 VDD.n459 2.801
R3160 VDD.n562 VDD.n561 2.801
R3161 VDD.n641 VDD.n638 2.801
R3162 VDD.n619 VDD.n618 2.801
R3163 VDD.n582 VDD.n581 2.801
R3164 VDD.n665 VDD.n664 2.801
R3165 VDD.n720 VDD.n719 2.801
R3166 VDD.n742 VDD.n741 2.801
R3167 VDD.n817 VDD.n813 2.801
R3168 VDD.n875 VDD.n874 2.801
R3169 VDD.n855 VDD.n782 2.801
R3170 VDD.n1010 VDD.n896 2.801
R3171 VDD.n984 VDD.n905 2.801
R3172 VDD.n979 VDD.n907 2.801
R3173 VDD.n939 VDD.n938 2.801
R3174 VDD.n945 VDD.n944 2.801
R3175 VDD.n386 VDD.t1420 2.73703
R3176 VDD.n397 VDD.t509 2.73703
R3177 VDD.n380 VDD.t1021 2.73703
R3178 VDD.n451 VDD.t1502 2.73703
R3179 VDD.n629 VDD.t1568 2.73703
R3180 VDD.n607 VDD.t341 2.73703
R3181 VDD.n848 VDD.t761 2.73703
R3182 VDD.n772 VDD.t763 2.73703
R3183 VDD.n791 VDD.t568 2.73703
R3184 VDD.n920 VDD.t1541 2.73703
R3185 VDD.n610 VDD.t1580 2.61116
R3186 VDD.n632 VDD.t497 2.61116
R3187 VDD VDD.t44 2.31531
R3188 VDD VDD.n622 2.31531
R3189 VDD VDD.t619 2.31531
R3190 VDD.n368 VDD.t438 2.2755
R3191 VDD.n464 VDD.t1976 2.2755
R3192 VDD.n452 VDD.t2092 2.2755
R3193 VDD.n443 VDD.t1648 2.2755
R3194 VDD.n489 VDD.t950 2.2755
R3195 VDD.n605 VDD.t434 2.2755
R3196 VDD.n597 VDD.t930 2.2755
R3197 VDD.n690 VDD.t460 2.2755
R3198 VDD.n700 VDD.t1362 2.2755
R3199 VDD.n801 VDD.t1068 2.2755
R3200 VDD.n378 VDD.t1650 2.10455
R3201 VDD.n378 VDD.t1015 2.10455
R3202 VDD.n472 VDD.t1974 2.10455
R3203 VDD.n472 VDD.t1572 2.10455
R3204 VDD.n544 VDD.t1286 2.10455
R3205 VDD.n544 VDD.t1667 2.10455
R3206 VDD.n466 VDD.t671 2.10455
R3207 VDD.n466 VDD.t1588 2.10455
R3208 VDD.n482 VDD.t495 2.10455
R3209 VDD.n482 VDD.t530 2.10455
R3210 VDD.n612 VDD.t1371 2.10455
R3211 VDD.n612 VDD.t1578 2.10455
R3212 VDD.n592 VDD.t1282 2.10455
R3213 VDD.n592 VDD.t1058 2.10455
R3214 VDD.n696 VDD.t907 2.10455
R3215 VDD.n696 VDD.t1984 2.10455
R3216 VDD.n708 VDD.t594 2.10455
R3217 VDD.n708 VDD.t1052 2.10455
R3218 VDD.n792 VDD.t1293 2.10455
R3219 VDD.n792 VDD.t987 2.10455
R3220 VDD.n376 VDD.t939 2.06607
R3221 VDD.n385 VDD.t1592 2.06607
R3222 VDD.n445 VDD.t2080 2.06607
R3223 VDD.n457 VDD.t1882 2.06607
R3224 VDD.n470 VDD.t1646 2.06607
R3225 VDD.n633 VDD.t1562 2.06607
R3226 VDD.n771 VDD.t1161 2.06607
R3227 VDD.n847 VDD.t1151 2.06607
R3228 VDD.n797 VDD.t1708 2.06607
R3229 VDD.n800 VDD.t1698 2.06607
R3230 VDD.n610 VDD.t1584 2.03739
R3231 VDD.n632 VDD.t578 2.03739
R3232 VDD.n1572 VDD.n1571 1.751
R3233 VDD.n1505 VDD.n1504 1.751
R3234 VDD.n1498 VDD.n1497 1.751
R3235 VDD.n66 VDD.n65 1.751
R3236 VDD.n86 VDD.n85 1.751
R3237 VDD.t293 VDD.n1422 1.751
R3238 VDD.t1179 VDD.n25 1.751
R3239 VDD.n1460 VDD.t1191 1.751
R3240 VDD.t1241 VDD.n1299 1.751
R3241 VDD.t88 VDD.n1365 1.751
R3242 VDD.t46 VDD.n1343 1.751
R3243 VDD.t2001 VDD.n107 1.751
R3244 VDD.t1750 VDD.n1200 1.751
R3245 VDD.t64 VDD.n1210 1.751
R3246 VDD.t1930 VDD.n178 1.751
R3247 VDD.t632 VDD.n239 1.751
R3248 VDD.t2059 VDD.n154 1.751
R3249 VDD.t838 VDD.n307 1.751
R3250 VDD.t1559 VDD.n259 1.751
R3251 VDD.n292 VDD.n291 1.751
R3252 VDD.t2063 VDD.n414 1.751
R3253 VDD.n393 VDD.n392 1.751
R3254 VDD.t1858 VDD.n334 1.751
R3255 VDD.n503 VDD.n496 1.751
R3256 VDD.n540 VDD.n539 1.751
R3257 VDD.t1232 VDD.n561 1.751
R3258 VDD.n643 VDD.n638 1.751
R3259 VDD.n620 VDD.n619 1.751
R3260 VDD.t575 VDD.n581 1.751
R3261 VDD.n688 VDD.n664 1.751
R3262 VDD.n721 VDD.n720 1.751
R3263 VDD.t678 VDD.n741 1.751
R3264 VDD.t1347 VDD.n813 1.751
R3265 VDD.t429 VDD.n874 1.751
R3266 VDD.n856 VDD.n855 1.751
R3267 VDD.n1011 VDD.n1010 1.751
R3268 VDD.n984 VDD.n983 1.751
R3269 VDD.n980 VDD.n979 1.751
R3270 VDD.n940 VDD.n939 1.751
R3271 VDD.n946 VDD.n945 1.751
R3272 VDD.n386 VDD.t646 1.73383
R3273 VDD.n397 VDD.t1965 1.73383
R3274 VDD.n380 VDD.t1759 1.73383
R3275 VDD.n451 VDD.t1719 1.73383
R3276 VDD.n629 VDD.t1967 1.73383
R3277 VDD.n607 VDD.t160 1.73383
R3278 VDD.n848 VDD.t1863 1.73383
R3279 VDD.n772 VDD.t245 1.73383
R3280 VDD.n791 VDD.t1850 1.73383
R3281 VDD.n920 VDD.t1846 1.73383
R3282 VDD.n15 VDD.n10 1.66865
R3283 VDD.n92 VDD.n87 1.66865
R3284 VDD.n1561 VDD.n1556 1.66865
R3285 VDD.n1433 VDD.n1428 1.66865
R3286 VDD.n1375 VDD.n1370 1.66865
R3287 VDD.n1310 VDD.n1305 1.66865
R3288 VDD.n1246 VDD.n1241 1.66865
R3289 VDD.n118 VDD.n113 1.66865
R3290 VDD.n249 VDD.n244 1.66865
R3291 VDD.n188 VDD.n183 1.66865
R3292 VDD.n1189 VDD.n1184 1.66865
R3293 VDD.n317 VDD.n312 1.66865
R3294 VDD.n424 VDD.n419 1.66865
R3295 VDD.n345 VDD.n340 1.66865
R3296 VDD.n509 VDD.n504 1.66865
R3297 VDD.n571 VDD.n566 1.66865
R3298 VDD.n649 VDD.n644 1.66865
R3299 VDD.n1103 VDD.n1098 1.66865
R3300 VDD.n675 VDD.n670 1.66865
R3301 VDD.n751 VDD.n746 1.66865
R3302 VDD.n824 VDD.n819 1.66865
R3303 VDD.n884 VDD.n879 1.66865
R3304 VDD.n947 VDD.n934 1.66865
R3305 VDD.n1016 VDD.n1012 1.66865
R3306 VDD.n374 VDD.t1042 1.4923
R3307 VDD.n376 VDD.t941 1.4923
R3308 VDD.n385 VDD.t1594 1.4923
R3309 VDD.n384 VDD.t1284 1.4923
R3310 VDD.n532 VDD.t909 1.4923
R3311 VDD.n445 VDD.t2082 1.4923
R3312 VDD.n457 VDD.t1884 1.4923
R3313 VDD.n454 VDD.t1880 1.4923
R3314 VDD.n467 VDD.t436 1.4923
R3315 VDD.n470 VDD.t1644 1.4923
R3316 VDD.n635 VDD.t236 1.4923
R3317 VDD.n633 VDD.t1564 1.4923
R3318 VDD.n774 VDD.t970 1.4923
R3319 VDD.n771 VDD.t1159 1.4923
R3320 VDD.n847 VDD.t1153 1.4923
R3321 VDD.n783 VDD.t1149 1.4923
R3322 VDD.n796 VDD.t566 1.4923
R3323 VDD.n797 VDD.t1706 1.4923
R3324 VDD.n800 VDD.t1700 1.4923
R3325 VDD.n803 VDD.t1696 1.4923
R3326 VDD.n497 VDD.t948 0.539645
R3327 VDD.n1565 VDD.n1564 0.4415
R3328 VDD.n1564 VDD.n17 0.4415
R3329 VDD.n1249 VDD.n17 0.4415
R3330 VDD.n1250 VDD.n1249 0.4415
R3331 VDD.n1250 VDD.n1192 0.4415
R3332 VDD.n1192 VDD.n251 0.4415
R3333 VDD.n1107 VDD.n251 0.4415
R3334 VDD.n1107 VDD.n1106 0.4415
R3335 VDD.n1106 VDD.n573 0.4415
R3336 VDD.n1026 VDD.n573 0.4415
R3337 VDD.n1533 VDD.n1532 0.4415
R3338 VDD.n1533 VDD.n42 0.4415
R3339 VDD.n1270 VDD.n42 0.4415
R3340 VDD.n1270 VDD.n1269 0.4415
R3341 VDD.n1269 VDD.n146 0.4415
R3342 VDD.n1125 VDD.n146 0.4415
R3343 VDD.n1125 VDD.n1124 0.4415
R3344 VDD.n1124 VDD.n442 0.4415
R3345 VDD.n1046 VDD.n442 0.4415
R3346 VDD.n1046 VDD.n1045 0.4415
R3347 VDD.n1484 VDD.n1483 0.4415
R3348 VDD.n1483 VDD.n1414 0.4415
R3349 VDD.n1414 VDD.n1291 0.4415
R3350 VDD.n1291 VDD.n99 0.4415
R3351 VDD.n1143 VDD.n99 0.4415
R3352 VDD.n1143 VDD.n1142 0.4415
R3353 VDD.n1142 VDD.n326 0.4415
R3354 VDD.n1065 VDD.n326 0.4415
R3355 VDD.n1065 VDD.n1064 0.4415
R3356 VDD.n1064 VDD.n655 0.4415
R3357 VDD.n1130 VDD.n1129 0.3365
R3358 VDD.n1022 VDD.n1021 0.3365
R3359 VDD.n1002 VDD.n1001 0.3365
R3360 VDD.n996 VDD.n995 0.3365
R3361 VDD.n993 VDD.n992 0.3365
R3362 VDD.n972 VDD.n971 0.3365
R3363 VDD.n971 VDD.n970 0.3365
R3364 VDD.n970 VDD.n969 0.3365
R3365 VDD.n969 VDD.n968 0.3365
R3366 VDD.n968 VDD.n967 0.3365
R3367 VDD.n967 VDD.n966 0.3365
R3368 VDD.n966 VDD.n965 0.3365
R3369 VDD.n963 VDD.n962 0.3365
R3370 VDD.n959 VDD.n958 0.3365
R3371 VDD.n954 VDD.n953 0.3365
R3372 VDD.n953 VDD.n952 0.3365
R3373 VDD.n952 VDD.n951 0.3365
R3374 VDD.n530 VDD 0.3245
R3375 VDD.n1566 VDD 0.3185
R3376 VDD.n1563 VDD 0.3185
R3377 VDD.n1377 VDD 0.3185
R3378 VDD.n1248 VDD 0.3185
R3379 VDD.n1251 VDD 0.3185
R3380 VDD.n1191 VDD 0.3185
R3381 VDD.n426 VDD 0.3185
R3382 VDD.n1108 VDD 0.3185
R3383 VDD.n1105 VDD 0.3185
R3384 VDD.n753 VDD 0.3185
R3385 VDD.n1027 VDD 0.3185
R3386 VDD VDD.n1131 0.3035
R3387 VDD.n517 VDD 0.3005
R3388 VDD VDD.n836 0.299
R3389 VDD VDD.n1051 0.2855
R3390 VDD.n95 VDD 0.28475
R3391 VDD.n994 VDD.n989 0.284196
R3392 VDD.n997 VDD.n986 0.284196
R3393 VDD.n1000 VDD.n902 0.284196
R3394 VDD.n1003 VDD.n899 0.284196
R3395 VDD.n1005 VDD.n897 0.284196
R3396 VDD.n1023 VDD.n889 0.284196
R3397 VDD.n1020 VDD.n892 0.284196
R3398 VDD.n1019 VDD.n893 0.284196
R3399 VDD.n1129 VDD 0.2825
R3400 VDD VDD.n514 0.2825
R3401 VDD.n1049 VDD 0.2825
R3402 VDD.n1051 VDD 0.2825
R3403 VDD.n1043 VDD 0.2825
R3404 VDD.n1021 VDD 0.2825
R3405 VDD.n1024 VDD 0.2825
R3406 VDD VDD.n1004 0.2825
R3407 VDD VDD.n1002 0.2825
R3408 VDD VDD.n999 0.2825
R3409 VDD VDD.n996 0.2825
R3410 VDD VDD.n993 0.2825
R3411 VDD VDD.n972 0.2825
R3412 VDD VDD.n963 0.2825
R3413 VDD VDD.n961 0.2825
R3414 VDD VDD.n960 0.2825
R3415 VDD VDD.n959 0.2825
R3416 VDD VDD.n954 0.2825
R3417 VDD VDD.n950 0.2825
R3418 VDD.n1019 VDD 0.28175
R3419 VDD.n1020 VDD 0.28175
R3420 VDD.n1023 VDD 0.28175
R3421 VDD VDD.n1005 0.28175
R3422 VDD VDD.n1003 0.28175
R3423 VDD VDD.n1000 0.28175
R3424 VDD VDD.n997 0.28175
R3425 VDD VDD.n994 0.28175
R3426 VDD.n1081 VDD 0.2735
R3427 VDD.n1025 VDD.n887 0.2705
R3428 VDD.n96 VDD.n76 0.268543
R3429 VDD.n98 VDD.n74 0.268543
R3430 VDD.n1486 VDD.n73 0.268543
R3431 VDD.n1487 VDD.n72 0.268543
R3432 VDD.n1492 VDD.n1491 0.268543
R3433 VDD.n1530 VDD.n43 0.268543
R3434 VDD.n1529 VDD.n44 0.268543
R3435 VDD.n1528 VDD.n45 0.268543
R3436 VDD.n1527 VDD.n46 0.268543
R3437 VDD.n1526 VDD.n47 0.268543
R3438 VDD.n1525 VDD.n48 0.268543
R3439 VDD.n1524 VDD.n49 0.268543
R3440 VDD.n1522 VDD.n1507 0.268543
R3441 VDD.n1521 VDD.n1508 0.268543
R3442 VDD.n1520 VDD.n1509 0.268543
R3443 VDD.n1519 VDD.n1510 0.268543
R3444 VDD.n1518 VDD.n1511 0.268543
R3445 VDD.n1517 VDD.n1512 0.268543
R3446 VDD.n1516 VDD.n1513 0.268543
R3447 VDD.n1515 VDD.n1514 0.268543
R3448 VDD VDD.n9 0.268543
R3449 VDD VDD.n8 0.268543
R3450 VDD VDD.n7 0.268543
R3451 VDD VDD.n6 0.268543
R3452 VDD VDD.n5 0.268543
R3453 VDD VDD.n4 0.268543
R3454 VDD VDD.n3 0.268543
R3455 VDD VDD.n2 0.268543
R3456 VDD VDD.n52 0.268543
R3457 VDD VDD.n53 0.268543
R3458 VDD VDD.n54 0.268543
R3459 VDD VDD.n55 0.268543
R3460 VDD VDD.n56 0.268543
R3461 VDD VDD.n57 0.268543
R3462 VDD VDD.n58 0.268543
R3463 VDD VDD.n59 0.268543
R3464 VDD.n1435 VDD.n1427 0.268543
R3465 VDD.n1436 VDD.n1426 0.268543
R3466 VDD.n1437 VDD.n1425 0.268543
R3467 VDD.n1438 VDD.n1424 0.268543
R3468 VDD.n1442 VDD.n1439 0.268543
R3469 VDD.n1441 VDD.n1440 0.268543
R3470 VDD.n1481 VDD.n1415 0.268543
R3471 VDD.n1480 VDD.n1416 0.268543
R3472 VDD.n1479 VDD.n1417 0.268543
R3473 VDD.n1478 VDD.n1418 0.268543
R3474 VDD.n1477 VDD.n1419 0.268543
R3475 VDD.n1476 VDD.n1420 0.268543
R3476 VDD.n1475 VDD.n1421 0.268543
R3477 VDD.n1474 VDD.n1448 0.268543
R3478 VDD.n1473 VDD.n1449 0.268543
R3479 VDD.n1472 VDD.n1450 0.268543
R3480 VDD.n1471 VDD.n1451 0.268543
R3481 VDD.n1470 VDD.n1452 0.268543
R3482 VDD.n1469 VDD.n1453 0.268543
R3483 VDD.n1468 VDD.n1454 0.268543
R3484 VDD.n1467 VDD.n1455 0.268543
R3485 VDD.n1465 VDD.n1462 0.268543
R3486 VDD.n1464 VDD.n1463 0.268543
R3487 VDD.n1535 VDD.n41 0.268543
R3488 VDD.n1536 VDD.n40 0.268543
R3489 VDD.n1537 VDD.n39 0.268543
R3490 VDD.n1538 VDD.n38 0.268543
R3491 VDD.n1539 VDD.n37 0.268543
R3492 VDD.n1540 VDD.n36 0.268543
R3493 VDD.n1541 VDD.n35 0.268543
R3494 VDD.n1542 VDD.n34 0.268543
R3495 VDD.n1543 VDD.n33 0.268543
R3496 VDD.n1544 VDD.n32 0.268543
R3497 VDD.n1545 VDD.n31 0.268543
R3498 VDD.n1546 VDD.n30 0.268543
R3499 VDD.n1547 VDD.n29 0.268543
R3500 VDD.n1548 VDD.n28 0.268543
R3501 VDD.n1549 VDD.n27 0.268543
R3502 VDD VDD.n24 0.268543
R3503 VDD VDD.n23 0.268543
R3504 VDD VDD.n22 0.268543
R3505 VDD VDD.n21 0.268543
R3506 VDD VDD.n20 0.268543
R3507 VDD VDD.n19 0.268543
R3508 VDD VDD.n18 0.268543
R3509 VDD VDD.n1550 0.268543
R3510 VDD.n1312 VDD.n1304 0.268543
R3511 VDD.n1313 VDD.n1303 0.268543
R3512 VDD.n1314 VDD.n1302 0.268543
R3513 VDD.n1315 VDD.n1301 0.268543
R3514 VDD.n1319 VDD.n1316 0.268543
R3515 VDD.n1318 VDD.n1317 0.268543
R3516 VDD.n1412 VDD.n1292 0.268543
R3517 VDD.n1411 VDD.n1293 0.268543
R3518 VDD.n1410 VDD.n1294 0.268543
R3519 VDD.n1409 VDD.n1295 0.268543
R3520 VDD.n1408 VDD.n1296 0.268543
R3521 VDD.n1407 VDD.n1297 0.268543
R3522 VDD.n1406 VDD.n1298 0.268543
R3523 VDD.n1405 VDD.n1325 0.268543
R3524 VDD.n1404 VDD.n1326 0.268543
R3525 VDD.n1403 VDD.n1327 0.268543
R3526 VDD.n1402 VDD.n1328 0.268543
R3527 VDD.n1401 VDD.n1329 0.268543
R3528 VDD.n1400 VDD.n1330 0.268543
R3529 VDD.n1399 VDD.n1331 0.268543
R3530 VDD.n1398 VDD.n1332 0.268543
R3531 VDD.n1396 VDD.n1334 0.268543
R3532 VDD.n1395 VDD.n1335 0.268543
R3533 VDD.n1393 VDD.n1336 0.268543
R3534 VDD.n1392 VDD.n1337 0.268543
R3535 VDD.n1391 VDD.n1338 0.268543
R3536 VDD.n1390 VDD.n1339 0.268543
R3537 VDD.n1389 VDD.n1340 0.268543
R3538 VDD.n1388 VDD.n1341 0.268543
R3539 VDD.n1387 VDD.n1342 0.268543
R3540 VDD.n1386 VDD.n1348 0.268543
R3541 VDD.n1385 VDD.n1349 0.268543
R3542 VDD.n1384 VDD.n1350 0.268543
R3543 VDD.n1383 VDD.n1351 0.268543
R3544 VDD.n1382 VDD.n1352 0.268543
R3545 VDD.n1381 VDD.n1353 0.268543
R3546 VDD.n1380 VDD.n1354 0.268543
R3547 VDD.n1379 VDD.n1355 0.268543
R3548 VDD VDD.n1364 0.268543
R3549 VDD VDD.n1363 0.268543
R3550 VDD VDD.n1362 0.268543
R3551 VDD VDD.n1361 0.268543
R3552 VDD VDD.n1360 0.268543
R3553 VDD VDD.n1359 0.268543
R3554 VDD VDD.n1358 0.268543
R3555 VDD VDD.n1357 0.268543
R3556 VDD.n120 VDD.n112 0.268543
R3557 VDD.n121 VDD.n111 0.268543
R3558 VDD.n122 VDD.n110 0.268543
R3559 VDD.n123 VDD.n109 0.268543
R3560 VDD.n127 VDD.n124 0.268543
R3561 VDD.n126 VDD.n125 0.268543
R3562 VDD.n1289 VDD.n100 0.268543
R3563 VDD.n1288 VDD.n101 0.268543
R3564 VDD.n1287 VDD.n102 0.268543
R3565 VDD.n1286 VDD.n103 0.268543
R3566 VDD.n1285 VDD.n104 0.268543
R3567 VDD.n1284 VDD.n105 0.268543
R3568 VDD.n1283 VDD.n106 0.268543
R3569 VDD.n1282 VDD.n133 0.268543
R3570 VDD.n1281 VDD.n134 0.268543
R3571 VDD.n1280 VDD.n135 0.268543
R3572 VDD.n1279 VDD.n136 0.268543
R3573 VDD.n1278 VDD.n137 0.268543
R3574 VDD.n1277 VDD.n138 0.268543
R3575 VDD.n1276 VDD.n139 0.268543
R3576 VDD.n1275 VDD.n140 0.268543
R3577 VDD.n1273 VDD.n142 0.268543
R3578 VDD.n1272 VDD.n143 0.268543
R3579 VDD.n145 VDD.n144 0.268543
R3580 VDD.n1221 VDD.n1220 0.268543
R3581 VDD.n1222 VDD.n1219 0.268543
R3582 VDD.n1223 VDD.n1218 0.268543
R3583 VDD.n1224 VDD.n1217 0.268543
R3584 VDD.n1225 VDD.n1216 0.268543
R3585 VDD.n1226 VDD.n1215 0.268543
R3586 VDD.n1227 VDD.n1209 0.268543
R3587 VDD.n1228 VDD.n1208 0.268543
R3588 VDD.n1229 VDD.n1207 0.268543
R3589 VDD.n1230 VDD.n1206 0.268543
R3590 VDD.n1231 VDD.n1205 0.268543
R3591 VDD.n1232 VDD.n1204 0.268543
R3592 VDD.n1233 VDD.n1203 0.268543
R3593 VDD.n1234 VDD.n1202 0.268543
R3594 VDD VDD.n1199 0.268543
R3595 VDD VDD.n1198 0.268543
R3596 VDD VDD.n1197 0.268543
R3597 VDD VDD.n1196 0.268543
R3598 VDD VDD.n1195 0.268543
R3599 VDD VDD.n1194 0.268543
R3600 VDD VDD.n1193 0.268543
R3601 VDD VDD.n1235 0.268543
R3602 VDD.n190 VDD.n177 0.268543
R3603 VDD.n191 VDD.n176 0.268543
R3604 VDD.n192 VDD.n175 0.268543
R3605 VDD.n193 VDD.n174 0.268543
R3606 VDD.n195 VDD.n172 0.268543
R3607 VDD.n196 VDD.n171 0.268543
R3608 VDD.n198 VDD.n170 0.268543
R3609 VDD.n199 VDD.n169 0.268543
R3610 VDD.n200 VDD.n168 0.268543
R3611 VDD.n201 VDD.n167 0.268543
R3612 VDD.n202 VDD.n166 0.268543
R3613 VDD.n203 VDD.n165 0.268543
R3614 VDD.n204 VDD.n164 0.268543
R3615 VDD.n205 VDD.n163 0.268543
R3616 VDD.n206 VDD.n162 0.268543
R3617 VDD.n207 VDD.n161 0.268543
R3618 VDD.n208 VDD.n160 0.268543
R3619 VDD.n209 VDD.n159 0.268543
R3620 VDD.n210 VDD.n158 0.268543
R3621 VDD.n211 VDD.n157 0.268543
R3622 VDD.n212 VDD.n156 0.268543
R3623 VDD.n216 VDD.n213 0.268543
R3624 VDD.n215 VDD.n214 0.268543
R3625 VDD.n1267 VDD.n147 0.268543
R3626 VDD.n1266 VDD.n148 0.268543
R3627 VDD.n1265 VDD.n149 0.268543
R3628 VDD.n1264 VDD.n150 0.268543
R3629 VDD.n1263 VDD.n151 0.268543
R3630 VDD.n1262 VDD.n152 0.268543
R3631 VDD.n1261 VDD.n153 0.268543
R3632 VDD.n1260 VDD.n222 0.268543
R3633 VDD.n1259 VDD.n223 0.268543
R3634 VDD.n1258 VDD.n224 0.268543
R3635 VDD.n1257 VDD.n225 0.268543
R3636 VDD.n1256 VDD.n226 0.268543
R3637 VDD.n1255 VDD.n227 0.268543
R3638 VDD.n1254 VDD.n228 0.268543
R3639 VDD.n1253 VDD.n229 0.268543
R3640 VDD VDD.n238 0.268543
R3641 VDD VDD.n237 0.268543
R3642 VDD VDD.n236 0.268543
R3643 VDD VDD.n235 0.268543
R3644 VDD VDD.n234 0.268543
R3645 VDD VDD.n233 0.268543
R3646 VDD VDD.n232 0.268543
R3647 VDD VDD.n231 0.268543
R3648 VDD.n319 VDD.n306 0.268543
R3649 VDD.n320 VDD.n305 0.268543
R3650 VDD.n321 VDD.n304 0.268543
R3651 VDD.n322 VDD.n303 0.268543
R3652 VDD.n324 VDD.n301 0.268543
R3653 VDD.n325 VDD.n300 0.268543
R3654 VDD.n1145 VDD.n299 0.268543
R3655 VDD.n1146 VDD.n298 0.268543
R3656 VDD.n1147 VDD.n297 0.268543
R3657 VDD.n1148 VDD.n296 0.268543
R3658 VDD.n1149 VDD.n295 0.268543
R3659 VDD.n1150 VDD.n294 0.268543
R3660 VDD.n1151 VDD.n293 0.268543
R3661 VDD.n1152 VDD.n286 0.268543
R3662 VDD.n1153 VDD.n285 0.268543
R3663 VDD.n1154 VDD.n284 0.268543
R3664 VDD.n1155 VDD.n283 0.268543
R3665 VDD.n1156 VDD.n282 0.268543
R3666 VDD.n1157 VDD.n281 0.268543
R3667 VDD.n1158 VDD.n280 0.268543
R3668 VDD.n1159 VDD.n279 0.268543
R3669 VDD.n1161 VDD.n276 0.268543
R3670 VDD.n1163 VDD.n275 0.268543
R3671 VDD.n1164 VDD.n274 0.268543
R3672 VDD.n1165 VDD.n273 0.268543
R3673 VDD.n1166 VDD.n272 0.268543
R3674 VDD.n1167 VDD.n271 0.268543
R3675 VDD.n1168 VDD.n270 0.268543
R3676 VDD.n1169 VDD.n269 0.268543
R3677 VDD.n1170 VDD.n268 0.268543
R3678 VDD.n1171 VDD.n267 0.268543
R3679 VDD.n1172 VDD.n266 0.268543
R3680 VDD.n1173 VDD.n265 0.268543
R3681 VDD.n1174 VDD.n264 0.268543
R3682 VDD.n1175 VDD.n263 0.268543
R3683 VDD.n1176 VDD.n262 0.268543
R3684 VDD.n1177 VDD.n261 0.268543
R3685 VDD VDD.n258 0.268543
R3686 VDD VDD.n257 0.268543
R3687 VDD VDD.n256 0.268543
R3688 VDD VDD.n255 0.268543
R3689 VDD VDD.n254 0.268543
R3690 VDD VDD.n253 0.268543
R3691 VDD VDD.n252 0.268543
R3692 VDD VDD.n1178 0.268543
R3693 VDD VDD.n277 0.268543
R3694 VDD.n347 VDD.n339 0.268543
R3695 VDD.n348 VDD.n338 0.268543
R3696 VDD.n349 VDD.n337 0.268543
R3697 VDD.n350 VDD.n336 0.268543
R3698 VDD.n354 VDD.n351 0.268543
R3699 VDD.n353 VDD.n352 0.268543
R3700 VDD.n1140 VDD.n327 0.268543
R3701 VDD.n1139 VDD.n328 0.268543
R3702 VDD.n1138 VDD.n329 0.268543
R3703 VDD.n1137 VDD.n330 0.268543
R3704 VDD.n1136 VDD.n331 0.268543
R3705 VDD.n1135 VDD.n332 0.268543
R3706 VDD.n1134 VDD.n333 0.268543
R3707 VDD.n1133 VDD.n363 0.268543
R3708 VDD.n1132 VDD.n364 0.268543
R3709 VDD.n1131 VDD.n366 0.268543
R3710 VDD.n1130 VDD.n370 0.268543
R3711 VDD.n1129 VDD.n371 0.268543
R3712 VDD.n440 VDD.n379 0.268543
R3713 VDD.n439 VDD.n381 0.268543
R3714 VDD.n438 VDD.n382 0.268543
R3715 VDD.n437 VDD.n383 0.268543
R3716 VDD.n435 VDD.n396 0.268543
R3717 VDD.n434 VDD.n398 0.268543
R3718 VDD.n433 VDD.n399 0.268543
R3719 VDD.n432 VDD.n400 0.268543
R3720 VDD.n431 VDD.n401 0.268543
R3721 VDD.n430 VDD.n402 0.268543
R3722 VDD.n429 VDD.n403 0.268543
R3723 VDD.n428 VDD.n404 0.268543
R3724 VDD VDD.n413 0.268543
R3725 VDD VDD.n412 0.268543
R3726 VDD VDD.n411 0.268543
R3727 VDD VDD.n410 0.268543
R3728 VDD VDD.n409 0.268543
R3729 VDD VDD.n408 0.268543
R3730 VDD VDD.n407 0.268543
R3731 VDD VDD.n406 0.268543
R3732 VDD VDD.n362 0.268543
R3733 VDD VDD.n361 0.268543
R3734 VDD VDD.n360 0.268543
R3735 VDD.n511 VDD.n495 0.268543
R3736 VDD.n512 VDD.n493 0.268543
R3737 VDD.n513 VDD.n491 0.268543
R3738 VDD.n514 VDD.n488 0.268543
R3739 VDD.n516 VDD.n486 0.268543
R3740 VDD.n517 VDD.n484 0.268543
R3741 VDD.n519 VDD.n483 0.268543
R3742 VDD.n520 VDD.n481 0.268543
R3743 VDD.n521 VDD.n480 0.268543
R3744 VDD.n522 VDD.n479 0.268543
R3745 VDD.n523 VDD.n478 0.268543
R3746 VDD.n524 VDD.n477 0.268543
R3747 VDD.n1115 VDD.n546 0.268543
R3748 VDD.n1114 VDD.n547 0.268543
R3749 VDD.n1113 VDD.n548 0.268543
R3750 VDD.n1112 VDD.n549 0.268543
R3751 VDD.n1111 VDD.n550 0.268543
R3752 VDD.n1110 VDD.n551 0.268543
R3753 VDD VDD.n560 0.268543
R3754 VDD VDD.n559 0.268543
R3755 VDD VDD.n558 0.268543
R3756 VDD VDD.n557 0.268543
R3757 VDD VDD.n556 0.268543
R3758 VDD VDD.n555 0.268543
R3759 VDD VDD.n554 0.268543
R3760 VDD VDD.n553 0.268543
R3761 VDD.n651 VDD.n637 0.268543
R3762 VDD.n1074 VDD.n602 0.268543
R3763 VDD.n1083 VDD.n591 0.268543
R3764 VDD.n1084 VDD.n590 0.268543
R3765 VDD.n1085 VDD.n589 0.268543
R3766 VDD.n1086 VDD.n588 0.268543
R3767 VDD.n1087 VDD.n587 0.268543
R3768 VDD.n1088 VDD.n586 0.268543
R3769 VDD.n1089 VDD.n585 0.268543
R3770 VDD.n1090 VDD.n584 0.268543
R3771 VDD.n1091 VDD.n583 0.268543
R3772 VDD VDD.n580 0.268543
R3773 VDD VDD.n579 0.268543
R3774 VDD VDD.n578 0.268543
R3775 VDD VDD.n577 0.268543
R3776 VDD VDD.n576 0.268543
R3777 VDD VDD.n575 0.268543
R3778 VDD VDD.n574 0.268543
R3779 VDD VDD.n1092 0.268543
R3780 VDD VDD.n623 0.268543
R3781 VDD VDD.n624 0.268543
R3782 VDD VDD.n625 0.268543
R3783 VDD VDD.n626 0.268543
R3784 VDD VDD.n627 0.268543
R3785 VDD.n677 VDD.n669 0.268543
R3786 VDD.n678 VDD.n668 0.268543
R3787 VDD.n679 VDD.n667 0.268543
R3788 VDD.n680 VDD.n666 0.268543
R3789 VDD.n682 VDD.n681 0.268543
R3790 VDD.n657 VDD.n656 0.268543
R3791 VDD.n1062 VDD.n658 0.268543
R3792 VDD.n1061 VDD.n659 0.268543
R3793 VDD.n1060 VDD.n660 0.268543
R3794 VDD.n1059 VDD.n661 0.268543
R3795 VDD.n1052 VDD.n699 0.268543
R3796 VDD.n1051 VDD.n702 0.268543
R3797 VDD.n1049 VDD.n705 0.268543
R3798 VDD.n1048 VDD.n706 0.268543
R3799 VDD.n769 VDD.n707 0.268543
R3800 VDD.n768 VDD.n709 0.268543
R3801 VDD.n767 VDD.n710 0.268543
R3802 VDD.n766 VDD.n711 0.268543
R3803 VDD.n765 VDD.n712 0.268543
R3804 VDD.n764 VDD.n713 0.268543
R3805 VDD.n763 VDD.n714 0.268543
R3806 VDD.n762 VDD.n724 0.268543
R3807 VDD.n761 VDD.n725 0.268543
R3808 VDD.n760 VDD.n726 0.268543
R3809 VDD.n759 VDD.n727 0.268543
R3810 VDD.n758 VDD.n728 0.268543
R3811 VDD.n757 VDD.n729 0.268543
R3812 VDD.n756 VDD.n730 0.268543
R3813 VDD.n755 VDD.n731 0.268543
R3814 VDD VDD.n740 0.268543
R3815 VDD VDD.n739 0.268543
R3816 VDD VDD.n738 0.268543
R3817 VDD VDD.n737 0.268543
R3818 VDD VDD.n736 0.268543
R3819 VDD VDD.n735 0.268543
R3820 VDD VDD.n734 0.268543
R3821 VDD VDD.n733 0.268543
R3822 VDD.n826 VDD.n812 0.268543
R3823 VDD.n827 VDD.n811 0.268543
R3824 VDD.n828 VDD.n810 0.268543
R3825 VDD.n829 VDD.n809 0.268543
R3826 VDD.n831 VDD.n807 0.268543
R3827 VDD.n832 VDD.n806 0.268543
R3828 VDD.n840 VDD.n790 0.268543
R3829 VDD.n841 VDD.n789 0.268543
R3830 VDD.n842 VDD.n788 0.268543
R3831 VDD.n843 VDD.n787 0.268543
R3832 VDD.n844 VDD.n786 0.268543
R3833 VDD.n845 VDD.n785 0.268543
R3834 VDD.n1042 VDD.n775 0.268543
R3835 VDD.n1041 VDD.n776 0.268543
R3836 VDD.n1040 VDD.n777 0.268543
R3837 VDD.n1039 VDD.n778 0.268543
R3838 VDD.n1038 VDD.n779 0.268543
R3839 VDD.n1037 VDD.n780 0.268543
R3840 VDD.n1036 VDD.n857 0.268543
R3841 VDD.n1035 VDD.n858 0.268543
R3842 VDD.n1034 VDD.n859 0.268543
R3843 VDD.n1033 VDD.n860 0.268543
R3844 VDD.n1032 VDD.n861 0.268543
R3845 VDD.n1031 VDD.n862 0.268543
R3846 VDD.n1030 VDD.n863 0.268543
R3847 VDD.n1029 VDD.n864 0.268543
R3848 VDD VDD.n873 0.268543
R3849 VDD VDD.n872 0.268543
R3850 VDD VDD.n871 0.268543
R3851 VDD VDD.n870 0.268543
R3852 VDD VDD.n869 0.268543
R3853 VDD VDD.n868 0.268543
R3854 VDD VDD.n867 0.268543
R3855 VDD VDD.n866 0.268543
R3856 VDD.n950 VDD.n930 0.268543
R3857 VDD.n951 VDD.n929 0.268543
R3858 VDD.n952 VDD.n928 0.268543
R3859 VDD.n953 VDD.n927 0.268543
R3860 VDD.n954 VDD.n926 0.268543
R3861 VDD.n956 VDD.n924 0.268543
R3862 VDD.n958 VDD.n923 0.268543
R3863 VDD.n959 VDD.n922 0.268543
R3864 VDD.n961 VDD.n919 0.268543
R3865 VDD.n962 VDD.n918 0.268543
R3866 VDD.n963 VDD.n917 0.268543
R3867 VDD.n965 VDD.n915 0.268543
R3868 VDD.n966 VDD.n914 0.268543
R3869 VDD.n967 VDD.n913 0.268543
R3870 VDD.n968 VDD.n912 0.268543
R3871 VDD.n969 VDD.n911 0.268543
R3872 VDD.n970 VDD.n910 0.268543
R3873 VDD.n971 VDD.n909 0.268543
R3874 VDD.n972 VDD.n908 0.268543
R3875 VDD.n974 VDD.n973 0.268543
R3876 VDD.n992 VDD.n991 0.268543
R3877 VDD.n993 VDD.n990 0.268543
R3878 VDD.n995 VDD.n988 0.268543
R3879 VDD.n996 VDD.n987 0.268543
R3880 VDD.n999 VDD.n903 0.268543
R3881 VDD.n1001 VDD.n901 0.268543
R3882 VDD.n1002 VDD.n900 0.268543
R3883 VDD.n1004 VDD.n898 0.268543
R3884 VDD.n887 VDD.n886 0.268543
R3885 VDD.n1024 VDD.n888 0.268543
R3886 VDD.n1022 VDD.n890 0.268543
R3887 VDD.n1021 VDD.n891 0.268543
R3888 VDD VDD.n1120 0.2645
R3889 VDD.n529 VDD.n528 0.2615
R3890 VDD.n531 VDD.n461 0.252891
R3891 VDD.n1067 VDD.n628 0.252891
R3892 VDD.n846 VDD.n784 0.252891
R3893 VDD VDD.n1487 0.2525
R3894 VDD VDD.n1486 0.2525
R3895 VDD VDD.n1549 0.2525
R3896 VDD VDD.n1548 0.2525
R3897 VDD VDD.n1547 0.2525
R3898 VDD VDD.n1546 0.2525
R3899 VDD VDD.n1545 0.2525
R3900 VDD VDD.n1544 0.2525
R3901 VDD VDD.n1543 0.2525
R3902 VDD.n1541 VDD 0.2525
R3903 VDD.n1540 VDD 0.2525
R3904 VDD.n1539 VDD 0.2525
R3905 VDD.n1538 VDD 0.2525
R3906 VDD.n1537 VDD 0.2525
R3907 VDD.n1536 VDD 0.2525
R3908 VDD.n1467 VDD 0.2525
R3909 VDD.n1468 VDD 0.2525
R3910 VDD.n1469 VDD 0.2525
R3911 VDD.n1470 VDD 0.2525
R3912 VDD.n1471 VDD 0.2525
R3913 VDD.n1472 VDD 0.2525
R3914 VDD.n1473 VDD 0.2525
R3915 VDD VDD.n1475 0.2525
R3916 VDD VDD.n1476 0.2525
R3917 VDD VDD.n1477 0.2525
R3918 VDD VDD.n1478 0.2525
R3919 VDD VDD.n1479 0.2525
R3920 VDD VDD.n1480 0.2525
R3921 VDD VDD.n1438 0.2525
R3922 VDD VDD.n1437 0.2525
R3923 VDD VDD.n1436 0.2525
R3924 VDD.n1379 VDD 0.2525
R3925 VDD.n1380 VDD 0.2525
R3926 VDD.n1381 VDD 0.2525
R3927 VDD.n1382 VDD 0.2525
R3928 VDD.n1383 VDD 0.2525
R3929 VDD.n1384 VDD 0.2525
R3930 VDD.n1385 VDD 0.2525
R3931 VDD VDD.n1387 0.2525
R3932 VDD VDD.n1388 0.2525
R3933 VDD VDD.n1389 0.2525
R3934 VDD VDD.n1390 0.2525
R3935 VDD VDD.n1391 0.2525
R3936 VDD VDD.n1392 0.2525
R3937 VDD.n1398 VDD 0.2525
R3938 VDD.n1399 VDD 0.2525
R3939 VDD.n1400 VDD 0.2525
R3940 VDD.n1401 VDD 0.2525
R3941 VDD.n1402 VDD 0.2525
R3942 VDD.n1403 VDD 0.2525
R3943 VDD.n1404 VDD 0.2525
R3944 VDD VDD.n1406 0.2525
R3945 VDD VDD.n1407 0.2525
R3946 VDD VDD.n1408 0.2525
R3947 VDD VDD.n1409 0.2525
R3948 VDD VDD.n1410 0.2525
R3949 VDD VDD.n1411 0.2525
R3950 VDD VDD.n1315 0.2525
R3951 VDD VDD.n1314 0.2525
R3952 VDD VDD.n1313 0.2525
R3953 VDD VDD.n1234 0.2525
R3954 VDD VDD.n1233 0.2525
R3955 VDD VDD.n1232 0.2525
R3956 VDD VDD.n1231 0.2525
R3957 VDD VDD.n1230 0.2525
R3958 VDD VDD.n1229 0.2525
R3959 VDD VDD.n1228 0.2525
R3960 VDD.n1226 VDD 0.2525
R3961 VDD.n1225 VDD 0.2525
R3962 VDD.n1224 VDD 0.2525
R3963 VDD.n1223 VDD 0.2525
R3964 VDD.n1222 VDD 0.2525
R3965 VDD.n1221 VDD 0.2525
R3966 VDD.n1275 VDD 0.2525
R3967 VDD.n1276 VDD 0.2525
R3968 VDD.n1277 VDD 0.2525
R3969 VDD.n1278 VDD 0.2525
R3970 VDD.n1279 VDD 0.2525
R3971 VDD.n1280 VDD 0.2525
R3972 VDD.n1281 VDD 0.2525
R3973 VDD VDD.n1283 0.2525
R3974 VDD VDD.n1284 0.2525
R3975 VDD VDD.n1285 0.2525
R3976 VDD VDD.n1286 0.2525
R3977 VDD VDD.n1287 0.2525
R3978 VDD VDD.n1288 0.2525
R3979 VDD VDD.n123 0.2525
R3980 VDD VDD.n122 0.2525
R3981 VDD VDD.n121 0.2525
R3982 VDD.n1253 VDD 0.2525
R3983 VDD.n1254 VDD 0.2525
R3984 VDD.n1255 VDD 0.2525
R3985 VDD.n1256 VDD 0.2525
R3986 VDD.n1257 VDD 0.2525
R3987 VDD.n1258 VDD 0.2525
R3988 VDD.n1259 VDD 0.2525
R3989 VDD VDD.n1261 0.2525
R3990 VDD VDD.n1262 0.2525
R3991 VDD VDD.n1263 0.2525
R3992 VDD VDD.n1264 0.2525
R3993 VDD VDD.n1265 0.2525
R3994 VDD VDD.n1266 0.2525
R3995 VDD VDD.n212 0.2525
R3996 VDD VDD.n211 0.2525
R3997 VDD VDD.n210 0.2525
R3998 VDD VDD.n209 0.2525
R3999 VDD VDD.n208 0.2525
R4000 VDD VDD.n207 0.2525
R4001 VDD VDD.n206 0.2525
R4002 VDD.n204 VDD 0.2525
R4003 VDD.n203 VDD 0.2525
R4004 VDD.n202 VDD 0.2525
R4005 VDD.n201 VDD 0.2525
R4006 VDD.n200 VDD 0.2525
R4007 VDD.n199 VDD 0.2525
R4008 VDD VDD.n193 0.2525
R4009 VDD VDD.n192 0.2525
R4010 VDD VDD.n191 0.2525
R4011 VDD VDD.n1177 0.2525
R4012 VDD VDD.n1176 0.2525
R4013 VDD VDD.n1175 0.2525
R4014 VDD VDD.n1174 0.2525
R4015 VDD VDD.n1173 0.2525
R4016 VDD VDD.n1172 0.2525
R4017 VDD VDD.n1171 0.2525
R4018 VDD.n1169 VDD 0.2525
R4019 VDD.n1168 VDD 0.2525
R4020 VDD.n1167 VDD 0.2525
R4021 VDD.n1166 VDD 0.2525
R4022 VDD.n1165 VDD 0.2525
R4023 VDD.n1164 VDD 0.2525
R4024 VDD.n1151 VDD 0.2525
R4025 VDD.n1150 VDD 0.2525
R4026 VDD.n1149 VDD 0.2525
R4027 VDD.n1148 VDD 0.2525
R4028 VDD.n1147 VDD 0.2525
R4029 VDD.n1146 VDD 0.2525
R4030 VDD VDD.n322 0.2525
R4031 VDD VDD.n321 0.2525
R4032 VDD VDD.n320 0.2525
R4033 VDD.n428 VDD 0.2525
R4034 VDD.n429 VDD 0.2525
R4035 VDD.n430 VDD 0.2525
R4036 VDD.n432 VDD 0.2525
R4037 VDD VDD.n434 0.2525
R4038 VDD VDD.n1134 0.2525
R4039 VDD VDD.n1135 0.2525
R4040 VDD VDD.n1136 0.2525
R4041 VDD VDD.n1137 0.2525
R4042 VDD VDD.n1138 0.2525
R4043 VDD VDD.n1139 0.2525
R4044 VDD VDD.n350 0.2525
R4045 VDD VDD.n349 0.2525
R4046 VDD VDD.n348 0.2525
R4047 VDD.n1110 VDD 0.2525
R4048 VDD.n1111 VDD 0.2525
R4049 VDD.n1112 VDD 0.2525
R4050 VDD.n1113 VDD 0.2525
R4051 VDD.n1114 VDD 0.2525
R4052 VDD.n1115 VDD 0.2525
R4053 VDD.n524 VDD 0.2525
R4054 VDD.n523 VDD 0.2525
R4055 VDD.n522 VDD 0.2525
R4056 VDD VDD.n1091 0.2525
R4057 VDD VDD.n1090 0.2525
R4058 VDD VDD.n1089 0.2525
R4059 VDD VDD.n1088 0.2525
R4060 VDD VDD.n1087 0.2525
R4061 VDD VDD.n1086 0.2525
R4062 VDD VDD.n1085 0.2525
R4063 VDD VDD.n654 0.2525
R4064 VDD VDD.n651 0.2525
R4065 VDD.n755 VDD 0.2525
R4066 VDD.n756 VDD 0.2525
R4067 VDD.n757 VDD 0.2525
R4068 VDD.n758 VDD 0.2525
R4069 VDD.n759 VDD 0.2525
R4070 VDD.n760 VDD 0.2525
R4071 VDD.n761 VDD 0.2525
R4072 VDD VDD.n763 0.2525
R4073 VDD VDD.n764 0.2525
R4074 VDD VDD.n765 0.2525
R4075 VDD VDD.n766 0.2525
R4076 VDD.n1029 VDD 0.2525
R4077 VDD.n1030 VDD 0.2525
R4078 VDD.n1031 VDD 0.2525
R4079 VDD.n1032 VDD 0.2525
R4080 VDD.n1033 VDD 0.2525
R4081 VDD.n1034 VDD 0.2525
R4082 VDD.n1035 VDD 0.2525
R4083 VDD VDD.n1037 0.2525
R4084 VDD VDD.n1038 0.2525
R4085 VDD VDD.n1039 0.2525
R4086 VDD.n845 VDD 0.2525
R4087 VDD.n844 VDD 0.2525
R4088 VDD.n843 VDD 0.2525
R4089 VDD.n841 VDD 0.2525
R4090 VDD.n832 VDD 0.2525
R4091 VDD VDD.n829 0.2525
R4092 VDD VDD.n828 0.2525
R4093 VDD VDD.n827 0.2525
R4094 VDD VDD.n826 0.2525
R4095 VDD.n1127 VDD.n1126 0.251
R4096 VDD VDD.n1489 0.25025
R4097 VDD VDD.n957 0.2495
R4098 VDD.n1488 VDD 0.24875
R4099 VDD.n1072 VDD 0.2405
R4100 VDD.n1565 VDD 0.237875
R4101 VDD.n1532 VDD 0.237875
R4102 VDD.n1484 VDD 0.237875
R4103 VDD.n974 VDD.n770 0.236
R4104 VDD VDD.n1079 0.2315
R4105 VDD.n527 VDD 0.23
R4106 VDD.n1082 VDD 0.2285
R4107 VDD.n769 VDD 0.2285
R4108 VDD.n1053 VDD 0.2225
R4109 VDD.n960 VDD 0.2225
R4110 VDD VDD.n1485 0.2195
R4111 VDD VDD.n1118 0.2195
R4112 VDD VDD.n1076 0.2195
R4113 VDD VDD.n1066 0.2195
R4114 VDD.n653 VDD 0.2195
R4115 VDD.n1055 VDD 0.2165
R4116 VDD.n441 VDD 0.215
R4117 VDD.n1133 VDD 0.2135
R4118 VDD VDD.n512 0.2105
R4119 VDD.n989 VDD 0.209848
R4120 VDD.n986 VDD 0.209848
R4121 VDD.n902 VDD 0.209848
R4122 VDD.n899 VDD 0.209848
R4123 VDD.n897 VDD 0.209848
R4124 VDD.n889 VDD 0.209848
R4125 VDD.n892 VDD 0.209848
R4126 VDD.n893 VDD 0.209848
R4127 VDD VDD.n1127 0.2075
R4128 VDD VDD.n534 0.2075
R4129 VDD.n652 VDD 0.2075
R4130 VDD.n518 VDD.n517 0.2015
R4131 VDD.n514 VDD 0.2015
R4132 VDD VDD.n1542 0.1985
R4133 VDD.n1474 VDD 0.1985
R4134 VDD VDD.n1435 0.1985
R4135 VDD.n1386 VDD 0.1985
R4136 VDD.n1405 VDD 0.1985
R4137 VDD VDD.n1312 0.1985
R4138 VDD VDD.n1227 0.1985
R4139 VDD.n1282 VDD 0.1985
R4140 VDD VDD.n120 0.1985
R4141 VDD.n1260 VDD 0.1985
R4142 VDD VDD.n205 0.1985
R4143 VDD VDD.n190 0.1985
R4144 VDD VDD.n1170 0.1985
R4145 VDD VDD.n319 0.1985
R4146 VDD.n431 VDD 0.1985
R4147 VDD.n433 VDD 0.1985
R4148 VDD.n436 VDD 0.1985
R4149 VDD.n438 VDD 0.1985
R4150 VDD.n439 VDD 0.1985
R4151 VDD VDD.n347 0.1985
R4152 VDD VDD.n520 0.1985
R4153 VDD VDD.n1084 0.1985
R4154 VDD.n762 VDD 0.1985
R4155 VDD.n1036 VDD 0.1985
R4156 VDD.n1042 VDD 0.1985
R4157 VDD.n838 VDD 0.1985
R4158 VDD VDD.n835 0.1955
R4159 VDD.n94 VDD 0.19475
R4160 VDD.n1117 VDD 0.1925
R4161 VDD.n534 VDD 0.1925
R4162 VDD.n1535 VDD.n1534 0.185
R4163 VDD.n1394 VDD.n1393 0.185
R4164 VDD.n1271 VDD.n145 0.185
R4165 VDD.n1268 VDD.n1267 0.185
R4166 VDD.n1069 VDD 0.1775
R4167 VDD.n1054 VDD 0.1775
R4168 VDD.n76 VDD 0.17463
R4169 VDD.n74 VDD 0.17463
R4170 VDD.n73 VDD 0.17463
R4171 VDD.n72 VDD 0.17463
R4172 VDD.n1491 VDD 0.17463
R4173 VDD.n43 VDD 0.17463
R4174 VDD.n44 VDD 0.17463
R4175 VDD.n45 VDD 0.17463
R4176 VDD.n46 VDD 0.17463
R4177 VDD.n47 VDD 0.17463
R4178 VDD.n48 VDD 0.17463
R4179 VDD.n49 VDD 0.17463
R4180 VDD.n1507 VDD 0.17463
R4181 VDD.n1508 VDD 0.17463
R4182 VDD.n1509 VDD 0.17463
R4183 VDD.n1510 VDD 0.17463
R4184 VDD.n1511 VDD 0.17463
R4185 VDD.n1512 VDD 0.17463
R4186 VDD.n1513 VDD 0.17463
R4187 VDD.n1514 VDD 0.17463
R4188 VDD.n9 VDD 0.17463
R4189 VDD.n8 VDD 0.17463
R4190 VDD.n7 VDD 0.17463
R4191 VDD.n6 VDD 0.17463
R4192 VDD.n5 VDD 0.17463
R4193 VDD.n4 VDD 0.17463
R4194 VDD.n3 VDD 0.17463
R4195 VDD.n2 VDD 0.17463
R4196 VDD.n52 VDD 0.17463
R4197 VDD.n53 VDD 0.17463
R4198 VDD.n54 VDD 0.17463
R4199 VDD.n55 VDD 0.17463
R4200 VDD.n56 VDD 0.17463
R4201 VDD.n57 VDD 0.17463
R4202 VDD.n58 VDD 0.17463
R4203 VDD.n59 VDD 0.17463
R4204 VDD.n1427 VDD 0.17463
R4205 VDD.n1426 VDD 0.17463
R4206 VDD.n1425 VDD 0.17463
R4207 VDD.n1424 VDD 0.17463
R4208 VDD.n1439 VDD 0.17463
R4209 VDD.n1440 VDD 0.17463
R4210 VDD.n1415 VDD 0.17463
R4211 VDD.n1416 VDD 0.17463
R4212 VDD.n1417 VDD 0.17463
R4213 VDD.n1418 VDD 0.17463
R4214 VDD.n1419 VDD 0.17463
R4215 VDD.n1420 VDD 0.17463
R4216 VDD.n1421 VDD 0.17463
R4217 VDD.n1448 VDD 0.17463
R4218 VDD.n1449 VDD 0.17463
R4219 VDD.n1450 VDD 0.17463
R4220 VDD.n1451 VDD 0.17463
R4221 VDD.n1452 VDD 0.17463
R4222 VDD.n1453 VDD 0.17463
R4223 VDD.n1454 VDD 0.17463
R4224 VDD.n1455 VDD 0.17463
R4225 VDD.n1462 VDD 0.17463
R4226 VDD.n1463 VDD 0.17463
R4227 VDD.n41 VDD 0.17463
R4228 VDD.n40 VDD 0.17463
R4229 VDD.n39 VDD 0.17463
R4230 VDD.n38 VDD 0.17463
R4231 VDD.n37 VDD 0.17463
R4232 VDD.n36 VDD 0.17463
R4233 VDD.n35 VDD 0.17463
R4234 VDD.n34 VDD 0.17463
R4235 VDD.n33 VDD 0.17463
R4236 VDD.n32 VDD 0.17463
R4237 VDD.n31 VDD 0.17463
R4238 VDD.n30 VDD 0.17463
R4239 VDD.n29 VDD 0.17463
R4240 VDD.n28 VDD 0.17463
R4241 VDD.n27 VDD 0.17463
R4242 VDD.n24 VDD 0.17463
R4243 VDD.n23 VDD 0.17463
R4244 VDD.n22 VDD 0.17463
R4245 VDD.n21 VDD 0.17463
R4246 VDD.n20 VDD 0.17463
R4247 VDD.n19 VDD 0.17463
R4248 VDD.n18 VDD 0.17463
R4249 VDD.n1550 VDD 0.17463
R4250 VDD.n1304 VDD 0.17463
R4251 VDD.n1303 VDD 0.17463
R4252 VDD.n1302 VDD 0.17463
R4253 VDD.n1301 VDD 0.17463
R4254 VDD.n1316 VDD 0.17463
R4255 VDD.n1317 VDD 0.17463
R4256 VDD.n1292 VDD 0.17463
R4257 VDD.n1293 VDD 0.17463
R4258 VDD.n1294 VDD 0.17463
R4259 VDD.n1295 VDD 0.17463
R4260 VDD.n1296 VDD 0.17463
R4261 VDD.n1297 VDD 0.17463
R4262 VDD.n1298 VDD 0.17463
R4263 VDD.n1325 VDD 0.17463
R4264 VDD.n1326 VDD 0.17463
R4265 VDD.n1327 VDD 0.17463
R4266 VDD.n1328 VDD 0.17463
R4267 VDD.n1329 VDD 0.17463
R4268 VDD.n1330 VDD 0.17463
R4269 VDD.n1331 VDD 0.17463
R4270 VDD.n1332 VDD 0.17463
R4271 VDD.n1334 VDD 0.17463
R4272 VDD.n1335 VDD 0.17463
R4273 VDD.n1336 VDD 0.17463
R4274 VDD.n1337 VDD 0.17463
R4275 VDD.n1338 VDD 0.17463
R4276 VDD.n1339 VDD 0.17463
R4277 VDD.n1340 VDD 0.17463
R4278 VDD.n1341 VDD 0.17463
R4279 VDD.n1342 VDD 0.17463
R4280 VDD.n1348 VDD 0.17463
R4281 VDD.n1349 VDD 0.17463
R4282 VDD.n1350 VDD 0.17463
R4283 VDD.n1351 VDD 0.17463
R4284 VDD.n1352 VDD 0.17463
R4285 VDD.n1353 VDD 0.17463
R4286 VDD.n1354 VDD 0.17463
R4287 VDD.n1355 VDD 0.17463
R4288 VDD.n1364 VDD 0.17463
R4289 VDD.n1363 VDD 0.17463
R4290 VDD.n1362 VDD 0.17463
R4291 VDD.n1361 VDD 0.17463
R4292 VDD.n1360 VDD 0.17463
R4293 VDD.n1359 VDD 0.17463
R4294 VDD.n1358 VDD 0.17463
R4295 VDD.n1357 VDD 0.17463
R4296 VDD.n112 VDD 0.17463
R4297 VDD.n111 VDD 0.17463
R4298 VDD.n110 VDD 0.17463
R4299 VDD.n109 VDD 0.17463
R4300 VDD.n124 VDD 0.17463
R4301 VDD.n125 VDD 0.17463
R4302 VDD.n100 VDD 0.17463
R4303 VDD.n101 VDD 0.17463
R4304 VDD.n102 VDD 0.17463
R4305 VDD.n103 VDD 0.17463
R4306 VDD.n104 VDD 0.17463
R4307 VDD.n105 VDD 0.17463
R4308 VDD.n106 VDD 0.17463
R4309 VDD.n133 VDD 0.17463
R4310 VDD.n134 VDD 0.17463
R4311 VDD.n135 VDD 0.17463
R4312 VDD.n136 VDD 0.17463
R4313 VDD.n137 VDD 0.17463
R4314 VDD.n138 VDD 0.17463
R4315 VDD.n139 VDD 0.17463
R4316 VDD.n140 VDD 0.17463
R4317 VDD.n142 VDD 0.17463
R4318 VDD.n143 VDD 0.17463
R4319 VDD.n144 VDD 0.17463
R4320 VDD.n1220 VDD 0.17463
R4321 VDD.n1219 VDD 0.17463
R4322 VDD.n1218 VDD 0.17463
R4323 VDD.n1217 VDD 0.17463
R4324 VDD.n1216 VDD 0.17463
R4325 VDD.n1215 VDD 0.17463
R4326 VDD.n1209 VDD 0.17463
R4327 VDD.n1208 VDD 0.17463
R4328 VDD.n1207 VDD 0.17463
R4329 VDD.n1206 VDD 0.17463
R4330 VDD.n1205 VDD 0.17463
R4331 VDD.n1204 VDD 0.17463
R4332 VDD.n1203 VDD 0.17463
R4333 VDD.n1202 VDD 0.17463
R4334 VDD.n1199 VDD 0.17463
R4335 VDD.n1198 VDD 0.17463
R4336 VDD.n1197 VDD 0.17463
R4337 VDD.n1196 VDD 0.17463
R4338 VDD.n1195 VDD 0.17463
R4339 VDD.n1194 VDD 0.17463
R4340 VDD.n1193 VDD 0.17463
R4341 VDD.n1235 VDD 0.17463
R4342 VDD.n177 VDD 0.17463
R4343 VDD.n176 VDD 0.17463
R4344 VDD.n175 VDD 0.17463
R4345 VDD.n174 VDD 0.17463
R4346 VDD.n172 VDD 0.17463
R4347 VDD.n171 VDD 0.17463
R4348 VDD.n170 VDD 0.17463
R4349 VDD.n169 VDD 0.17463
R4350 VDD.n168 VDD 0.17463
R4351 VDD.n167 VDD 0.17463
R4352 VDD.n166 VDD 0.17463
R4353 VDD.n165 VDD 0.17463
R4354 VDD.n164 VDD 0.17463
R4355 VDD.n163 VDD 0.17463
R4356 VDD.n162 VDD 0.17463
R4357 VDD.n161 VDD 0.17463
R4358 VDD.n160 VDD 0.17463
R4359 VDD.n159 VDD 0.17463
R4360 VDD.n158 VDD 0.17463
R4361 VDD.n157 VDD 0.17463
R4362 VDD.n156 VDD 0.17463
R4363 VDD.n213 VDD 0.17463
R4364 VDD.n214 VDD 0.17463
R4365 VDD.n147 VDD 0.17463
R4366 VDD.n148 VDD 0.17463
R4367 VDD.n149 VDD 0.17463
R4368 VDD.n150 VDD 0.17463
R4369 VDD.n151 VDD 0.17463
R4370 VDD.n152 VDD 0.17463
R4371 VDD.n153 VDD 0.17463
R4372 VDD.n222 VDD 0.17463
R4373 VDD.n223 VDD 0.17463
R4374 VDD.n224 VDD 0.17463
R4375 VDD.n225 VDD 0.17463
R4376 VDD.n226 VDD 0.17463
R4377 VDD.n227 VDD 0.17463
R4378 VDD.n228 VDD 0.17463
R4379 VDD.n229 VDD 0.17463
R4380 VDD.n238 VDD 0.17463
R4381 VDD.n237 VDD 0.17463
R4382 VDD.n236 VDD 0.17463
R4383 VDD.n235 VDD 0.17463
R4384 VDD.n234 VDD 0.17463
R4385 VDD.n233 VDD 0.17463
R4386 VDD.n232 VDD 0.17463
R4387 VDD.n231 VDD 0.17463
R4388 VDD.n306 VDD 0.17463
R4389 VDD.n305 VDD 0.17463
R4390 VDD.n304 VDD 0.17463
R4391 VDD.n303 VDD 0.17463
R4392 VDD.n301 VDD 0.17463
R4393 VDD.n300 VDD 0.17463
R4394 VDD.n299 VDD 0.17463
R4395 VDD.n298 VDD 0.17463
R4396 VDD.n297 VDD 0.17463
R4397 VDD.n296 VDD 0.17463
R4398 VDD.n295 VDD 0.17463
R4399 VDD.n294 VDD 0.17463
R4400 VDD.n293 VDD 0.17463
R4401 VDD.n286 VDD 0.17463
R4402 VDD.n285 VDD 0.17463
R4403 VDD.n284 VDD 0.17463
R4404 VDD.n283 VDD 0.17463
R4405 VDD.n282 VDD 0.17463
R4406 VDD.n281 VDD 0.17463
R4407 VDD.n280 VDD 0.17463
R4408 VDD.n279 VDD 0.17463
R4409 VDD.n276 VDD 0.17463
R4410 VDD.n275 VDD 0.17463
R4411 VDD.n274 VDD 0.17463
R4412 VDD.n273 VDD 0.17463
R4413 VDD.n272 VDD 0.17463
R4414 VDD.n271 VDD 0.17463
R4415 VDD.n270 VDD 0.17463
R4416 VDD.n269 VDD 0.17463
R4417 VDD.n268 VDD 0.17463
R4418 VDD.n267 VDD 0.17463
R4419 VDD.n266 VDD 0.17463
R4420 VDD.n265 VDD 0.17463
R4421 VDD.n264 VDD 0.17463
R4422 VDD.n263 VDD 0.17463
R4423 VDD.n262 VDD 0.17463
R4424 VDD.n261 VDD 0.17463
R4425 VDD.n258 VDD 0.17463
R4426 VDD.n257 VDD 0.17463
R4427 VDD.n256 VDD 0.17463
R4428 VDD.n255 VDD 0.17463
R4429 VDD.n254 VDD 0.17463
R4430 VDD.n253 VDD 0.17463
R4431 VDD.n252 VDD 0.17463
R4432 VDD.n1178 VDD 0.17463
R4433 VDD.n277 VDD 0.17463
R4434 VDD.n339 VDD 0.17463
R4435 VDD.n338 VDD 0.17463
R4436 VDD.n337 VDD 0.17463
R4437 VDD.n336 VDD 0.17463
R4438 VDD.n351 VDD 0.17463
R4439 VDD.n352 VDD 0.17463
R4440 VDD.n327 VDD 0.17463
R4441 VDD.n328 VDD 0.17463
R4442 VDD.n329 VDD 0.17463
R4443 VDD.n330 VDD 0.17463
R4444 VDD.n331 VDD 0.17463
R4445 VDD.n332 VDD 0.17463
R4446 VDD.n333 VDD 0.17463
R4447 VDD.n363 VDD 0.17463
R4448 VDD.n364 VDD 0.17463
R4449 VDD.n366 VDD 0.17463
R4450 VDD.n370 VDD 0.17463
R4451 VDD.n371 VDD 0.17463
R4452 VDD.n379 VDD 0.17463
R4453 VDD.n381 VDD 0.17463
R4454 VDD.n382 VDD 0.17463
R4455 VDD.n383 VDD 0.17463
R4456 VDD.n396 VDD 0.17463
R4457 VDD.n398 VDD 0.17463
R4458 VDD.n399 VDD 0.17463
R4459 VDD.n400 VDD 0.17463
R4460 VDD.n401 VDD 0.17463
R4461 VDD.n402 VDD 0.17463
R4462 VDD.n403 VDD 0.17463
R4463 VDD.n404 VDD 0.17463
R4464 VDD.n413 VDD 0.17463
R4465 VDD.n412 VDD 0.17463
R4466 VDD.n411 VDD 0.17463
R4467 VDD.n410 VDD 0.17463
R4468 VDD.n409 VDD 0.17463
R4469 VDD.n408 VDD 0.17463
R4470 VDD.n407 VDD 0.17463
R4471 VDD.n406 VDD 0.17463
R4472 VDD.n362 VDD 0.17463
R4473 VDD.n361 VDD 0.17463
R4474 VDD.n360 VDD 0.17463
R4475 VDD.n495 VDD 0.17463
R4476 VDD.n493 VDD 0.17463
R4477 VDD.n491 VDD 0.17463
R4478 VDD.n488 VDD 0.17463
R4479 VDD.n486 VDD 0.17463
R4480 VDD.n484 VDD 0.17463
R4481 VDD.n483 VDD 0.17463
R4482 VDD.n481 VDD 0.17463
R4483 VDD.n480 VDD 0.17463
R4484 VDD.n479 VDD 0.17463
R4485 VDD.n478 VDD 0.17463
R4486 VDD.n477 VDD 0.17463
R4487 VDD.n461 VDD 0.17463
R4488 VDD.n546 VDD 0.17463
R4489 VDD.n547 VDD 0.17463
R4490 VDD.n548 VDD 0.17463
R4491 VDD.n549 VDD 0.17463
R4492 VDD.n550 VDD 0.17463
R4493 VDD.n551 VDD 0.17463
R4494 VDD.n560 VDD 0.17463
R4495 VDD.n559 VDD 0.17463
R4496 VDD.n558 VDD 0.17463
R4497 VDD.n557 VDD 0.17463
R4498 VDD.n556 VDD 0.17463
R4499 VDD.n555 VDD 0.17463
R4500 VDD.n554 VDD 0.17463
R4501 VDD.n553 VDD 0.17463
R4502 VDD.n637 VDD 0.17463
R4503 VDD.n628 VDD 0.17463
R4504 VDD.n602 VDD 0.17463
R4505 VDD.n591 VDD 0.17463
R4506 VDD.n590 VDD 0.17463
R4507 VDD.n589 VDD 0.17463
R4508 VDD.n588 VDD 0.17463
R4509 VDD.n587 VDD 0.17463
R4510 VDD.n586 VDD 0.17463
R4511 VDD.n585 VDD 0.17463
R4512 VDD.n584 VDD 0.17463
R4513 VDD.n583 VDD 0.17463
R4514 VDD.n580 VDD 0.17463
R4515 VDD.n579 VDD 0.17463
R4516 VDD.n578 VDD 0.17463
R4517 VDD.n577 VDD 0.17463
R4518 VDD.n576 VDD 0.17463
R4519 VDD.n575 VDD 0.17463
R4520 VDD.n574 VDD 0.17463
R4521 VDD.n1092 VDD 0.17463
R4522 VDD.n623 VDD 0.17463
R4523 VDD.n624 VDD 0.17463
R4524 VDD.n625 VDD 0.17463
R4525 VDD.n626 VDD 0.17463
R4526 VDD.n627 VDD 0.17463
R4527 VDD.n669 VDD 0.17463
R4528 VDD.n668 VDD 0.17463
R4529 VDD.n667 VDD 0.17463
R4530 VDD.n666 VDD 0.17463
R4531 VDD.n681 VDD 0.17463
R4532 VDD.n656 VDD 0.17463
R4533 VDD.n658 VDD 0.17463
R4534 VDD.n659 VDD 0.17463
R4535 VDD.n660 VDD 0.17463
R4536 VDD.n661 VDD 0.17463
R4537 VDD.n699 VDD 0.17463
R4538 VDD.n702 VDD 0.17463
R4539 VDD.n705 VDD 0.17463
R4540 VDD.n706 VDD 0.17463
R4541 VDD.n707 VDD 0.17463
R4542 VDD.n709 VDD 0.17463
R4543 VDD.n710 VDD 0.17463
R4544 VDD.n711 VDD 0.17463
R4545 VDD.n712 VDD 0.17463
R4546 VDD.n713 VDD 0.17463
R4547 VDD.n714 VDD 0.17463
R4548 VDD.n724 VDD 0.17463
R4549 VDD.n725 VDD 0.17463
R4550 VDD.n726 VDD 0.17463
R4551 VDD.n727 VDD 0.17463
R4552 VDD.n728 VDD 0.17463
R4553 VDD.n729 VDD 0.17463
R4554 VDD.n730 VDD 0.17463
R4555 VDD.n731 VDD 0.17463
R4556 VDD.n740 VDD 0.17463
R4557 VDD.n739 VDD 0.17463
R4558 VDD.n738 VDD 0.17463
R4559 VDD.n737 VDD 0.17463
R4560 VDD.n736 VDD 0.17463
R4561 VDD.n735 VDD 0.17463
R4562 VDD.n734 VDD 0.17463
R4563 VDD.n733 VDD 0.17463
R4564 VDD.n812 VDD 0.17463
R4565 VDD.n811 VDD 0.17463
R4566 VDD.n810 VDD 0.17463
R4567 VDD.n809 VDD 0.17463
R4568 VDD.n807 VDD 0.17463
R4569 VDD.n806 VDD 0.17463
R4570 VDD.n790 VDD 0.17463
R4571 VDD.n789 VDD 0.17463
R4572 VDD.n788 VDD 0.17463
R4573 VDD.n787 VDD 0.17463
R4574 VDD.n786 VDD 0.17463
R4575 VDD.n785 VDD 0.17463
R4576 VDD.n784 VDD 0.17463
R4577 VDD.n775 VDD 0.17463
R4578 VDD.n776 VDD 0.17463
R4579 VDD.n777 VDD 0.17463
R4580 VDD.n778 VDD 0.17463
R4581 VDD.n779 VDD 0.17463
R4582 VDD.n780 VDD 0.17463
R4583 VDD.n857 VDD 0.17463
R4584 VDD.n858 VDD 0.17463
R4585 VDD.n859 VDD 0.17463
R4586 VDD.n860 VDD 0.17463
R4587 VDD.n861 VDD 0.17463
R4588 VDD.n862 VDD 0.17463
R4589 VDD.n863 VDD 0.17463
R4590 VDD.n864 VDD 0.17463
R4591 VDD.n873 VDD 0.17463
R4592 VDD.n872 VDD 0.17463
R4593 VDD.n871 VDD 0.17463
R4594 VDD.n870 VDD 0.17463
R4595 VDD.n869 VDD 0.17463
R4596 VDD.n868 VDD 0.17463
R4597 VDD.n867 VDD 0.17463
R4598 VDD.n866 VDD 0.17463
R4599 VDD.n930 VDD 0.17463
R4600 VDD.n929 VDD 0.17463
R4601 VDD.n928 VDD 0.17463
R4602 VDD.n927 VDD 0.17463
R4603 VDD.n926 VDD 0.17463
R4604 VDD.n924 VDD 0.17463
R4605 VDD.n923 VDD 0.17463
R4606 VDD.n922 VDD 0.17463
R4607 VDD.n919 VDD 0.17463
R4608 VDD.n918 VDD 0.17463
R4609 VDD.n917 VDD 0.17463
R4610 VDD.n915 VDD 0.17463
R4611 VDD.n914 VDD 0.17463
R4612 VDD.n913 VDD 0.17463
R4613 VDD.n912 VDD 0.17463
R4614 VDD.n911 VDD 0.17463
R4615 VDD.n910 VDD 0.17463
R4616 VDD.n909 VDD 0.17463
R4617 VDD.n908 VDD 0.17463
R4618 VDD.n973 VDD 0.17463
R4619 VDD.n991 VDD 0.17463
R4620 VDD.n990 VDD 0.17463
R4621 VDD.n988 VDD 0.17463
R4622 VDD.n987 VDD 0.17463
R4623 VDD.n903 VDD 0.17463
R4624 VDD.n901 VDD 0.17463
R4625 VDD.n900 VDD 0.17463
R4626 VDD.n898 VDD 0.17463
R4627 VDD.n886 VDD 0.17463
R4628 VDD.n888 VDD 0.17463
R4629 VDD.n890 VDD 0.17463
R4630 VDD.n891 VDD 0.17463
R4631 VDD.n837 VDD 0.1745
R4632 VDD.n528 VDD 0.170717
R4633 VDD.n529 VDD 0.170717
R4634 VDD.n530 VDD 0.170717
R4635 VDD.n1121 VDD 0.170717
R4636 VDD.n1120 VDD 0.170717
R4637 VDD.n1119 VDD 0.170717
R4638 VDD.n1071 VDD 0.170717
R4639 VDD.n1072 VDD 0.170717
R4640 VDD.n1073 VDD 0.170717
R4641 VDD.n1076 VDD 0.170717
R4642 VDD.n1077 VDD 0.170717
R4643 VDD.n1079 VDD 0.170717
R4644 VDD.n1058 VDD 0.170717
R4645 VDD.n1057 VDD 0.170717
R4646 VDD.n1056 VDD 0.170717
R4647 VDD.n834 VDD 0.170717
R4648 VDD.n835 VDD 0.170717
R4649 VDD.n836 VDD 0.170717
R4650 VDD.n89 VDD.n88 0.169912
R4651 VDD.n93 VDD.n88 0.169912
R4652 VDD.n83 VDD.n82 0.169912
R4653 VDD.n83 VDD.n75 0.169912
R4654 VDD.n63 VDD.n62 0.169912
R4655 VDD.n63 VDD.n60 0.169912
R4656 VDD.n1495 VDD.n1494 0.169912
R4657 VDD.n1496 VDD.n1495 0.169912
R4658 VDD.n1502 VDD.n1500 0.169912
R4659 VDD.n1506 VDD.n1500 0.169912
R4660 VDD.n1569 VDD.n1568 0.169912
R4661 VDD.n1570 VDD.n1569 0.169912
R4662 VDD.n12 VDD.n11 0.169912
R4663 VDD.n16 VDD.n11 0.169912
R4664 VDD.n1445 VDD.n1444 0.169912
R4665 VDD.n1446 VDD.n1445 0.169912
R4666 VDD.n1430 VDD.n1429 0.169912
R4667 VDD.n1434 VDD.n1429 0.169912
R4668 VDD.n1458 VDD.n1456 0.169912
R4669 VDD.n1461 VDD.n1456 0.169912
R4670 VDD.n1554 VDD.n1553 0.169912
R4671 VDD.n1553 VDD.n1552 0.169912
R4672 VDD.n1558 VDD.n1557 0.169912
R4673 VDD.n1562 VDD.n1557 0.169912
R4674 VDD.n1322 VDD.n1321 0.169912
R4675 VDD.n1323 VDD.n1322 0.169912
R4676 VDD.n1307 VDD.n1306 0.169912
R4677 VDD.n1311 VDD.n1306 0.169912
R4678 VDD.n1346 VDD.n1345 0.169912
R4679 VDD.n1345 VDD.n1333 0.169912
R4680 VDD.n1368 VDD.n1367 0.169912
R4681 VDD.n1367 VDD.n1356 0.169912
R4682 VDD.n1372 VDD.n1371 0.169912
R4683 VDD.n1376 VDD.n1371 0.169912
R4684 VDD.n130 VDD.n129 0.169912
R4685 VDD.n131 VDD.n130 0.169912
R4686 VDD.n115 VDD.n114 0.169912
R4687 VDD.n119 VDD.n114 0.169912
R4688 VDD.n1213 VDD.n1212 0.169912
R4689 VDD.n1212 VDD.n141 0.169912
R4690 VDD.n1239 VDD.n1238 0.169912
R4691 VDD.n1238 VDD.n1237 0.169912
R4692 VDD.n1243 VDD.n1242 0.169912
R4693 VDD.n1247 VDD.n1242 0.169912
R4694 VDD.n180 VDD.n179 0.169912
R4695 VDD.n180 VDD.n173 0.169912
R4696 VDD.n185 VDD.n184 0.169912
R4697 VDD.n189 VDD.n184 0.169912
R4698 VDD.n220 VDD.n219 0.169912
R4699 VDD.n219 VDD.n218 0.169912
R4700 VDD.n242 VDD.n241 0.169912
R4701 VDD.n241 VDD.n230 0.169912
R4702 VDD.n246 VDD.n245 0.169912
R4703 VDD.n250 VDD.n245 0.169912
R4704 VDD.n309 VDD.n308 0.169912
R4705 VDD.n309 VDD.n302 0.169912
R4706 VDD.n314 VDD.n313 0.169912
R4707 VDD.n318 VDD.n313 0.169912
R4708 VDD.n289 VDD.n288 0.169912
R4709 VDD.n289 VDD.n278 0.169912
R4710 VDD.n1182 VDD.n1181 0.169912
R4711 VDD.n1181 VDD.n1180 0.169912
R4712 VDD.n1186 VDD.n1185 0.169912
R4713 VDD.n1190 VDD.n1185 0.169912
R4714 VDD.n342 VDD.n341 0.169912
R4715 VDD.n346 VDD.n341 0.169912
R4716 VDD.n358 VDD.n357 0.169912
R4717 VDD.n357 VDD.n356 0.169912
R4718 VDD.n390 VDD.n389 0.169912
R4719 VDD.n390 VDD.n372 0.169912
R4720 VDD.n417 VDD.n416 0.169912
R4721 VDD.n416 VDD.n405 0.169912
R4722 VDD.n421 VDD.n420 0.169912
R4723 VDD.n425 VDD.n420 0.169912
R4724 VDD.n500 VDD.n499 0.169912
R4725 VDD.n500 VDD.n487 0.169912
R4726 VDD.n564 VDD.n563 0.169912
R4727 VDD.n563 VDD.n552 0.169912
R4728 VDD.n568 VDD.n567 0.169912
R4729 VDD.n572 VDD.n567 0.169912
R4730 VDD.n537 VDD.n536 0.169912
R4731 VDD.n538 VDD.n537 0.169912
R4732 VDD.n506 VDD.n505 0.169912
R4733 VDD.n510 VDD.n505 0.169912
R4734 VDD.n640 VDD.n639 0.169912
R4735 VDD.n640 VDD.n631 0.169912
R4736 VDD.n1096 VDD.n1095 0.169912
R4737 VDD.n1095 VDD.n1094 0.169912
R4738 VDD.n1100 VDD.n1099 0.169912
R4739 VDD.n1104 VDD.n1099 0.169912
R4740 VDD.n617 VDD.n616 0.169912
R4741 VDD.n617 VDD.n601 0.169912
R4742 VDD.n646 VDD.n645 0.169912
R4743 VDD.n650 VDD.n645 0.169912
R4744 VDD.n685 VDD.n684 0.169912
R4745 VDD.n686 VDD.n685 0.169912
R4746 VDD.n744 VDD.n743 0.169912
R4747 VDD.n743 VDD.n732 0.169912
R4748 VDD.n748 VDD.n747 0.169912
R4749 VDD.n752 VDD.n747 0.169912
R4750 VDD.n718 VDD.n717 0.169912
R4751 VDD.n718 VDD.n703 0.169912
R4752 VDD.n672 VDD.n671 0.169912
R4753 VDD.n676 VDD.n671 0.169912
R4754 VDD.n816 VDD.n815 0.169912
R4755 VDD.n816 VDD.n808 0.169912
R4756 VDD.n853 VDD.n852 0.169912
R4757 VDD.n854 VDD.n853 0.169912
R4758 VDD.n877 VDD.n876 0.169912
R4759 VDD.n876 VDD.n865 0.169912
R4760 VDD.n881 VDD.n880 0.169912
R4761 VDD.n885 VDD.n880 0.169912
R4762 VDD.n821 VDD.n820 0.169912
R4763 VDD.n825 VDD.n820 0.169912
R4764 VDD.n933 VDD.n931 0.169912
R4765 VDD.n949 VDD.n931 0.169912
R4766 VDD.n943 VDD.n942 0.169912
R4767 VDD.n943 VDD.n925 0.169912
R4768 VDD.n937 VDD.n936 0.169912
R4769 VDD.n937 VDD.n916 0.169912
R4770 VDD.n977 VDD.n976 0.169912
R4771 VDD.n978 VDD.n977 0.169912
R4772 VDD.n981 VDD.n904 0.169912
R4773 VDD.n985 VDD.n904 0.169912
R4774 VDD.n1008 VDD.n1007 0.169912
R4775 VDD.n1009 VDD.n1008 0.169912
R4776 VDD.n1013 VDD.n894 0.169912
R4777 VDD.n1017 VDD.n894 0.169912
R4778 VDD.n1515 VDD 0.1685
R4779 VDD VDD.n1515 0.1685
R4780 VDD.n1516 VDD 0.1685
R4781 VDD VDD.n1516 0.1685
R4782 VDD.n1517 VDD 0.1685
R4783 VDD VDD.n1517 0.1685
R4784 VDD.n1518 VDD 0.1685
R4785 VDD VDD.n1518 0.1685
R4786 VDD.n1519 VDD 0.1685
R4787 VDD VDD.n1519 0.1685
R4788 VDD.n1520 VDD 0.1685
R4789 VDD VDD.n1520 0.1685
R4790 VDD.n1521 VDD 0.1685
R4791 VDD VDD.n1521 0.1685
R4792 VDD VDD.n1524 0.1685
R4793 VDD.n1525 VDD 0.1685
R4794 VDD VDD.n1525 0.1685
R4795 VDD.n1526 VDD 0.1685
R4796 VDD VDD.n1526 0.1685
R4797 VDD.n1527 VDD 0.1685
R4798 VDD VDD.n1527 0.1685
R4799 VDD.n1528 VDD 0.1685
R4800 VDD VDD.n1528 0.1685
R4801 VDD.n1529 VDD 0.1685
R4802 VDD VDD.n1529 0.1685
R4803 VDD.n1530 VDD 0.1685
R4804 VDD.n1492 VDD 0.1685
R4805 VDD VDD.n1159 0.1685
R4806 VDD.n1159 VDD 0.1685
R4807 VDD VDD.n1158 0.1685
R4808 VDD.n1158 VDD 0.1685
R4809 VDD VDD.n1157 0.1685
R4810 VDD.n1157 VDD 0.1685
R4811 VDD VDD.n1156 0.1685
R4812 VDD.n1156 VDD 0.1685
R4813 VDD VDD.n1155 0.1685
R4814 VDD.n1155 VDD 0.1685
R4815 VDD VDD.n1154 0.1685
R4816 VDD.n1154 VDD 0.1685
R4817 VDD.n1153 VDD 0.1685
R4818 VDD VDD.n1059 0.1685
R4819 VDD.n1060 VDD 0.1685
R4820 VDD VDD.n1060 0.1685
R4821 VDD.n1061 VDD 0.1685
R4822 VDD VDD.n1061 0.1685
R4823 VDD.n1062 VDD 0.1685
R4824 VDD VDD.n657 0.1685
R4825 VDD.n682 VDD 0.1685
R4826 VDD VDD.n680 0.1685
R4827 VDD.n680 VDD 0.1685
R4828 VDD.n679 VDD 0.1685
R4829 VDD VDD.n678 0.1685
R4830 VDD.n678 VDD 0.1685
R4831 VDD.n1070 VDD 0.1625
R4832 VDD VDD.n526 0.1595
R4833 VDD.n1057 VDD 0.1565
R4834 VDD.n1162 VDD.n1161 0.152
R4835 VDD.n1048 VDD.n1047 0.152
R4836 VDD VDD.n949 0.151029
R4837 VDD.n1044 VDD 0.1475
R4838 VDD.n1118 VDD 0.146
R4839 VDD.n1127 VDD.n375 0.143441
R4840 VDD.n441 VDD.n377 0.143441
R4841 VDD.n534 VDD.n533 0.143441
R4842 VDD.n1122 VDD.n446 0.143441
R4843 VDD.n652 VDD.n636 0.143441
R4844 VDD.n653 VDD.n634 0.143441
R4845 VDD.n1123 VDD 0.143
R4846 VDD VDD.n437 0.1385
R4847 VDD.n521 VDD 0.1385
R4848 VDD VDD.n767 0.1385
R4849 VDD VDD.n1041 0.1385
R4850 VDD.n850 VDD 0.1385
R4851 VDD.n1482 VDD.n1481 0.1355
R4852 VDD.n1413 VDD.n1412 0.1355
R4853 VDD.n1290 VDD.n1289 0.1355
R4854 VDD.n198 VDD.n197 0.1355
R4855 VDD.n1145 VDD.n1144 0.1355
R4856 VDD.n1141 VDD.n1140 0.1355
R4857 VDD VDD.n527 0.1355
R4858 VDD.n519 VDD.n518 0.1355
R4859 VDD VDD.n513 0.1355
R4860 VDD.n512 VDD 0.1355
R4861 VDD.n1063 VDD 0.1355
R4862 VDD VDD.n850 0.131
R4863 VDD.n513 VDD 0.1265
R4864 VDD.n1077 VDD 0.1265
R4865 VDD VDD.n1057 0.1265
R4866 VDD.n526 VDD 0.1235
R4867 VDD.n1047 VDD 0.122
R4868 VDD VDD.n1055 0.1205
R4869 VDD.n1482 VDD 0.1175
R4870 VDD.n1413 VDD 0.1175
R4871 VDD.n1290 VDD 0.1175
R4872 VDD.n197 VDD 0.1175
R4873 VDD.n1144 VDD 0.1175
R4874 VDD.n1141 VDD 0.1175
R4875 VDD.n833 VDD 0.1175
R4876 VDD VDD.n653 0.11675
R4877 VDD.n525 VDD 0.115647
R4878 VDD.n527 VDD 0.115647
R4879 VDD.n1118 VDD 0.115647
R4880 VDD.n1116 VDD 0.115647
R4881 VDD.n1068 VDD 0.115647
R4882 VDD.n1070 VDD 0.115647
R4883 VDD.n1080 VDD 0.115647
R4884 VDD.n1082 VDD 0.115647
R4885 VDD.n1055 VDD 0.115647
R4886 VDD.n1053 VDD 0.115647
R4887 VDD.n837 VDD 0.115647
R4888 VDD.n839 VDD 0.115647
R4889 VDD.n1522 VDD 0.1145
R4890 VDD.n1524 VDD 0.1145
R4891 VDD VDD.n96 0.1145
R4892 VDD VDD.n1153 0.1145
R4893 VDD VDD.n1152 0.1145
R4894 VDD VDD.n511 0.1145
R4895 VDD VDD.n1068 0.1145
R4896 VDD.n768 VDD 0.1145
R4897 VDD.n1059 VDD 0.1145
R4898 VDD VDD.n679 0.1145
R4899 VDD VDD.n677 0.1145
R4900 VDD.n839 VDD 0.1145
R4901 VDD.n1073 VDD 0.1115
R4902 VDD.n1078 VDD.n1077 0.11
R4903 VDD VDD.n1082 0.1085
R4904 VDD VDD.n768 0.1085
R4905 VDD VDD.n839 0.1085
R4906 VDD VDD.n1054 0.1055
R4907 VDD.n526 VDD.n471 0.104196
R4908 VDD.n1117 VDD.n543 0.104196
R4909 VDD.n1069 VDD.n611 0.104196
R4910 VDD.n1081 VDD.n594 0.104196
R4911 VDD.n1054 VDD.n694 0.104196
R4912 VDD.n838 VDD.n795 0.104196
R4913 VDD.n1531 VDD.n1530 0.101
R4914 VDD VDD.n1078 0.101
R4915 VDD VDD.n837 0.095
R4916 VDD VDD.n531 0.0935
R4917 VDD.n1122 VDD 0.089
R4918 VDD VDD.n94 0.08825
R4919 VDD.n95 VDD.n78 0.0878529
R4920 VDD.n1489 VDD.n69 0.0878529
R4921 VDD.n436 VDD.n387 0.0878529
R4922 VDD.n654 VDD.n630 0.0878529
R4923 VDD.n850 VDD.n849 0.0878529
R4924 VDD.n1043 VDD.n773 0.0878529
R4925 VDD.n960 VDD.n921 0.0878529
R4926 VDD VDD.n530 0.0875
R4927 VDD.n1076 VDD 0.0875
R4928 VDD VDD.n1073 0.0875
R4929 VDD VDD.n1058 0.0875
R4930 VDD.n834 VDD 0.0875
R4931 VDD VDD.n1018 0.0875
R4932 VDD.n1567 VDD 0.0845
R4933 VDD.n1567 VDD 0.0845
R4934 VDD.n1523 VDD 0.0845
R4935 VDD.n1493 VDD 0.0845
R4936 VDD VDD.n1490 0.0845
R4937 VDD.n1490 VDD 0.0845
R4938 VDD.n1487 VDD 0.0845
R4939 VDD VDD.n97 0.0845
R4940 VDD.n97 VDD 0.0845
R4941 VDD.n1551 VDD 0.0845
R4942 VDD.n1551 VDD 0.0845
R4943 VDD.n1549 VDD 0.0845
R4944 VDD.n1548 VDD 0.0845
R4945 VDD.n1547 VDD 0.0845
R4946 VDD.n1546 VDD 0.0845
R4947 VDD.n1545 VDD 0.0845
R4948 VDD.n1544 VDD 0.0845
R4949 VDD.n1543 VDD 0.0845
R4950 VDD.n1542 VDD 0.0845
R4951 VDD VDD.n1540 0.0845
R4952 VDD VDD.n1539 0.0845
R4953 VDD VDD.n1538 0.0845
R4954 VDD VDD.n1537 0.0845
R4955 VDD VDD.n1536 0.0845
R4956 VDD VDD.n1535 0.0845
R4957 VDD.n1464 VDD 0.0845
R4958 VDD.n1465 VDD 0.0845
R4959 VDD.n1466 VDD 0.0845
R4960 VDD VDD.n1466 0.0845
R4961 VDD VDD.n1467 0.0845
R4962 VDD VDD.n1468 0.0845
R4963 VDD VDD.n1469 0.0845
R4964 VDD VDD.n1470 0.0845
R4965 VDD VDD.n1471 0.0845
R4966 VDD VDD.n1472 0.0845
R4967 VDD VDD.n1473 0.0845
R4968 VDD VDD.n1474 0.0845
R4969 VDD.n1476 VDD 0.0845
R4970 VDD.n1477 VDD 0.0845
R4971 VDD.n1478 VDD 0.0845
R4972 VDD.n1479 VDD 0.0845
R4973 VDD.n1480 VDD 0.0845
R4974 VDD.n1481 VDD 0.0845
R4975 VDD.n1441 VDD 0.0845
R4976 VDD.n1443 VDD 0.0845
R4977 VDD.n1443 VDD 0.0845
R4978 VDD.n1438 VDD 0.0845
R4979 VDD.n1437 VDD 0.0845
R4980 VDD.n1436 VDD 0.0845
R4981 VDD.n1378 VDD 0.0845
R4982 VDD VDD.n1378 0.0845
R4983 VDD VDD.n1379 0.0845
R4984 VDD VDD.n1380 0.0845
R4985 VDD VDD.n1381 0.0845
R4986 VDD VDD.n1382 0.0845
R4987 VDD VDD.n1383 0.0845
R4988 VDD VDD.n1384 0.0845
R4989 VDD VDD.n1385 0.0845
R4990 VDD VDD.n1386 0.0845
R4991 VDD.n1388 VDD 0.0845
R4992 VDD.n1389 VDD 0.0845
R4993 VDD.n1390 VDD 0.0845
R4994 VDD.n1391 VDD 0.0845
R4995 VDD.n1392 VDD 0.0845
R4996 VDD.n1393 VDD 0.0845
R4997 VDD.n1395 VDD 0.0845
R4998 VDD.n1396 VDD 0.0845
R4999 VDD.n1397 VDD 0.0845
R5000 VDD VDD.n1397 0.0845
R5001 VDD VDD.n1398 0.0845
R5002 VDD VDD.n1399 0.0845
R5003 VDD VDD.n1400 0.0845
R5004 VDD VDD.n1401 0.0845
R5005 VDD VDD.n1402 0.0845
R5006 VDD VDD.n1403 0.0845
R5007 VDD VDD.n1404 0.0845
R5008 VDD VDD.n1405 0.0845
R5009 VDD.n1407 VDD 0.0845
R5010 VDD.n1408 VDD 0.0845
R5011 VDD.n1409 VDD 0.0845
R5012 VDD.n1410 VDD 0.0845
R5013 VDD.n1411 VDD 0.0845
R5014 VDD.n1412 VDD 0.0845
R5015 VDD.n1318 VDD 0.0845
R5016 VDD.n1320 VDD 0.0845
R5017 VDD.n1320 VDD 0.0845
R5018 VDD.n1315 VDD 0.0845
R5019 VDD.n1314 VDD 0.0845
R5020 VDD.n1313 VDD 0.0845
R5021 VDD.n1236 VDD 0.0845
R5022 VDD.n1236 VDD 0.0845
R5023 VDD.n1234 VDD 0.0845
R5024 VDD.n1233 VDD 0.0845
R5025 VDD.n1232 VDD 0.0845
R5026 VDD.n1231 VDD 0.0845
R5027 VDD.n1230 VDD 0.0845
R5028 VDD.n1229 VDD 0.0845
R5029 VDD.n1228 VDD 0.0845
R5030 VDD.n1227 VDD 0.0845
R5031 VDD VDD.n1225 0.0845
R5032 VDD VDD.n1224 0.0845
R5033 VDD VDD.n1223 0.0845
R5034 VDD VDD.n1222 0.0845
R5035 VDD VDD.n1221 0.0845
R5036 VDD VDD.n145 0.0845
R5037 VDD.n1272 VDD 0.0845
R5038 VDD.n1273 VDD 0.0845
R5039 VDD.n1274 VDD 0.0845
R5040 VDD VDD.n1274 0.0845
R5041 VDD VDD.n1275 0.0845
R5042 VDD VDD.n1276 0.0845
R5043 VDD VDD.n1277 0.0845
R5044 VDD VDD.n1278 0.0845
R5045 VDD VDD.n1279 0.0845
R5046 VDD VDD.n1280 0.0845
R5047 VDD VDD.n1281 0.0845
R5048 VDD VDD.n1282 0.0845
R5049 VDD.n1284 VDD 0.0845
R5050 VDD.n1285 VDD 0.0845
R5051 VDD.n1286 VDD 0.0845
R5052 VDD.n1287 VDD 0.0845
R5053 VDD.n1288 VDD 0.0845
R5054 VDD.n1289 VDD 0.0845
R5055 VDD.n126 VDD 0.0845
R5056 VDD.n128 VDD 0.0845
R5057 VDD.n128 VDD 0.0845
R5058 VDD.n123 VDD 0.0845
R5059 VDD.n122 VDD 0.0845
R5060 VDD.n121 VDD 0.0845
R5061 VDD.n1252 VDD 0.0845
R5062 VDD VDD.n1252 0.0845
R5063 VDD VDD.n1253 0.0845
R5064 VDD VDD.n1254 0.0845
R5065 VDD VDD.n1255 0.0845
R5066 VDD VDD.n1256 0.0845
R5067 VDD VDD.n1257 0.0845
R5068 VDD VDD.n1258 0.0845
R5069 VDD VDD.n1259 0.0845
R5070 VDD VDD.n1260 0.0845
R5071 VDD.n1262 VDD 0.0845
R5072 VDD.n1263 VDD 0.0845
R5073 VDD.n1264 VDD 0.0845
R5074 VDD.n1265 VDD 0.0845
R5075 VDD.n1266 VDD 0.0845
R5076 VDD.n1267 VDD 0.0845
R5077 VDD.n215 VDD 0.0845
R5078 VDD.n216 VDD 0.0845
R5079 VDD.n217 VDD 0.0845
R5080 VDD.n217 VDD 0.0845
R5081 VDD.n212 VDD 0.0845
R5082 VDD.n211 VDD 0.0845
R5083 VDD.n210 VDD 0.0845
R5084 VDD.n209 VDD 0.0845
R5085 VDD.n208 VDD 0.0845
R5086 VDD.n207 VDD 0.0845
R5087 VDD.n206 VDD 0.0845
R5088 VDD.n205 VDD 0.0845
R5089 VDD VDD.n203 0.0845
R5090 VDD VDD.n202 0.0845
R5091 VDD VDD.n201 0.0845
R5092 VDD VDD.n200 0.0845
R5093 VDD VDD.n199 0.0845
R5094 VDD VDD.n198 0.0845
R5095 VDD VDD.n196 0.0845
R5096 VDD VDD.n194 0.0845
R5097 VDD.n194 VDD 0.0845
R5098 VDD.n193 VDD 0.0845
R5099 VDD.n192 VDD 0.0845
R5100 VDD.n191 VDD 0.0845
R5101 VDD.n1179 VDD 0.0845
R5102 VDD.n1179 VDD 0.0845
R5103 VDD.n1177 VDD 0.0845
R5104 VDD.n1176 VDD 0.0845
R5105 VDD.n1175 VDD 0.0845
R5106 VDD.n1174 VDD 0.0845
R5107 VDD.n1173 VDD 0.0845
R5108 VDD.n1172 VDD 0.0845
R5109 VDD.n1171 VDD 0.0845
R5110 VDD.n1170 VDD 0.0845
R5111 VDD VDD.n1168 0.0845
R5112 VDD VDD.n1167 0.0845
R5113 VDD VDD.n1166 0.0845
R5114 VDD VDD.n1164 0.0845
R5115 VDD VDD.n1160 0.0845
R5116 VDD.n1160 VDD 0.0845
R5117 VDD VDD.n1150 0.0845
R5118 VDD VDD.n1149 0.0845
R5119 VDD VDD.n1148 0.0845
R5120 VDD VDD.n1147 0.0845
R5121 VDD VDD.n1146 0.0845
R5122 VDD VDD.n1145 0.0845
R5123 VDD VDD.n325 0.0845
R5124 VDD VDD.n323 0.0845
R5125 VDD.n323 VDD 0.0845
R5126 VDD.n322 VDD 0.0845
R5127 VDD.n321 VDD 0.0845
R5128 VDD.n320 VDD 0.0845
R5129 VDD.n427 VDD 0.0845
R5130 VDD VDD.n427 0.0845
R5131 VDD VDD.n428 0.0845
R5132 VDD VDD.n429 0.0845
R5133 VDD VDD.n430 0.0845
R5134 VDD VDD.n431 0.0845
R5135 VDD VDD.n432 0.0845
R5136 VDD VDD.n433 0.0845
R5137 VDD.n435 VDD 0.0845
R5138 VDD VDD.n438 0.0845
R5139 VDD VDD.n1128 0.0845
R5140 VDD.n1135 VDD 0.0845
R5141 VDD.n1136 VDD 0.0845
R5142 VDD.n1137 VDD 0.0845
R5143 VDD.n1138 VDD 0.0845
R5144 VDD.n1139 VDD 0.0845
R5145 VDD.n1140 VDD 0.0845
R5146 VDD.n353 VDD 0.0845
R5147 VDD.n355 VDD 0.0845
R5148 VDD.n355 VDD 0.0845
R5149 VDD.n350 VDD 0.0845
R5150 VDD.n349 VDD 0.0845
R5151 VDD.n348 VDD 0.0845
R5152 VDD.n1109 VDD 0.0845
R5153 VDD VDD.n1109 0.0845
R5154 VDD VDD.n1110 0.0845
R5155 VDD VDD.n1111 0.0845
R5156 VDD VDD.n1112 0.0845
R5157 VDD VDD.n1114 0.0845
R5158 VDD.n535 VDD 0.0845
R5159 VDD.n535 VDD 0.0845
R5160 VDD VDD.n524 0.0845
R5161 VDD VDD.n523 0.0845
R5162 VDD VDD.n522 0.0845
R5163 VDD VDD.n515 0.0845
R5164 VDD.n515 VDD 0.0845
R5165 VDD.n1093 VDD 0.0845
R5166 VDD.n1093 VDD 0.0845
R5167 VDD.n1091 VDD 0.0845
R5168 VDD.n1090 VDD 0.0845
R5169 VDD.n1089 VDD 0.0845
R5170 VDD.n1088 VDD 0.0845
R5171 VDD.n1087 VDD 0.0845
R5172 VDD.n1086 VDD 0.0845
R5173 VDD.n1085 VDD 0.0845
R5174 VDD.n1075 VDD 0.0845
R5175 VDD.n654 VDD 0.0845
R5176 VDD.n754 VDD 0.0845
R5177 VDD VDD.n754 0.0845
R5178 VDD VDD.n755 0.0845
R5179 VDD VDD.n756 0.0845
R5180 VDD VDD.n757 0.0845
R5181 VDD VDD.n758 0.0845
R5182 VDD VDD.n759 0.0845
R5183 VDD VDD.n760 0.0845
R5184 VDD VDD.n761 0.0845
R5185 VDD VDD.n762 0.0845
R5186 VDD.n764 VDD 0.0845
R5187 VDD.n765 VDD 0.0845
R5188 VDD.n766 VDD 0.0845
R5189 VDD.n1050 VDD 0.0845
R5190 VDD VDD.n1050 0.0845
R5191 VDD.n683 VDD 0.0845
R5192 VDD.n683 VDD 0.0845
R5193 VDD.n1028 VDD 0.0845
R5194 VDD VDD.n1028 0.0845
R5195 VDD VDD.n1029 0.0845
R5196 VDD VDD.n1030 0.0845
R5197 VDD VDD.n1031 0.0845
R5198 VDD VDD.n1032 0.0845
R5199 VDD VDD.n1033 0.0845
R5200 VDD VDD.n1034 0.0845
R5201 VDD VDD.n1035 0.0845
R5202 VDD.n1038 VDD 0.0845
R5203 VDD.n1039 VDD 0.0845
R5204 VDD.n1040 VDD 0.0845
R5205 VDD.n851 VDD 0.0845
R5206 VDD.n851 VDD 0.0845
R5207 VDD VDD.n845 0.0845
R5208 VDD VDD.n844 0.0845
R5209 VDD VDD.n843 0.0845
R5210 VDD VDD.n841 0.0845
R5211 VDD VDD.n832 0.0845
R5212 VDD VDD.n831 0.0845
R5213 VDD VDD.n830 0.0845
R5214 VDD.n830 VDD 0.0845
R5215 VDD.n829 VDD 0.0845
R5216 VDD.n828 VDD 0.0845
R5217 VDD.n827 VDD 0.0845
R5218 VDD.n1006 VDD 0.0845
R5219 VDD.n1006 VDD 0.0845
R5220 VDD VDD.n998 0.0845
R5221 VDD.n998 VDD 0.0845
R5222 VDD.n975 VDD 0.0845
R5223 VDD.n975 VDD 0.0845
R5224 VDD VDD.n964 0.0845
R5225 VDD.n964 VDD 0.0845
R5226 VDD VDD.n955 0.0845
R5227 VDD.n955 VDD 0.0845
R5228 VDD.n1121 VDD 0.0815
R5229 VDD.n1058 VDD 0.0815
R5230 VDD VDD.n833 0.0815
R5231 VDD.n1018 VDD 0.0815
R5232 VDD VDD.n441 0.077
R5233 VDD VDD.n1117 0.0755
R5234 VDD.n387 VDD 0.0732941
R5235 VDD.n630 VDD 0.0732941
R5236 VDD.n849 VDD 0.0732941
R5237 VDD.n773 VDD 0.0732941
R5238 VDD.n921 VDD 0.0732941
R5239 VDD VDD.n436 0.071
R5240 VDD.n437 VDD 0.0695
R5241 VDD.n531 VDD 0.0695
R5242 VDD VDD.n1067 0.0695
R5243 VDD.n846 VDD 0.0695
R5244 VDD.n1531 VDD 0.068
R5245 VDD.n1534 VDD 0.068
R5246 VDD VDD.n1394 0.068
R5247 VDD VDD.n1271 0.068
R5248 VDD.n1268 VDD 0.068
R5249 VDD.n471 VDD 0.0670217
R5250 VDD.n543 VDD 0.0670217
R5251 VDD.n611 VDD 0.0670217
R5252 VDD.n594 VDD 0.0670217
R5253 VDD.n694 VDD 0.0670217
R5254 VDD.n795 VDD 0.0670217
R5255 VDD.n836 VDD 0.0665
R5256 VDD.n1025 VDD.n1024 0.0665
R5257 VDD.n367 VDD 0.0650652
R5258 VDD.n365 VDD 0.0650652
R5259 VDD.n463 VDD 0.0650652
R5260 VDD.n462 VDD 0.0650652
R5261 VDD.n449 VDD 0.0650652
R5262 VDD.n450 VDD 0.0650652
R5263 VDD.n448 VDD 0.0650652
R5264 VDD.n447 VDD 0.0650652
R5265 VDD.n492 VDD 0.0650652
R5266 VDD.n494 VDD 0.0650652
R5267 VDD.n604 VDD 0.0650652
R5268 VDD.n603 VDD 0.0650652
R5269 VDD.n600 VDD 0.0650652
R5270 VDD.n599 VDD 0.0650652
R5271 VDD.n662 VDD 0.0650652
R5272 VDD.n663 VDD 0.0650652
R5273 VDD.n698 VDD 0.0650652
R5274 VDD.n695 VDD 0.0650652
R5275 VDD.n805 VDD 0.0650652
R5276 VDD.n804 VDD 0.0650652
R5277 VDD VDD.n93 0.0640294
R5278 VDD.n97 VDD.n75 0.0640294
R5279 VDD.n1490 VDD.n60 0.0640294
R5280 VDD.n1496 VDD.n1493 0.0640294
R5281 VDD.n1523 VDD.n1506 0.0640294
R5282 VDD.n1570 VDD.n1567 0.0640294
R5283 VDD VDD.n16 0.0640294
R5284 VDD.n1446 VDD.n1443 0.0640294
R5285 VDD VDD.n1434 0.0640294
R5286 VDD.n1466 VDD.n1461 0.0640294
R5287 VDD.n1552 VDD.n1551 0.0640294
R5288 VDD VDD.n1562 0.0640294
R5289 VDD.n1323 VDD.n1320 0.0640294
R5290 VDD VDD.n1311 0.0640294
R5291 VDD.n1397 VDD.n1333 0.0640294
R5292 VDD.n1378 VDD.n1356 0.0640294
R5293 VDD VDD.n1376 0.0640294
R5294 VDD.n131 VDD.n128 0.0640294
R5295 VDD VDD.n119 0.0640294
R5296 VDD.n1274 VDD.n141 0.0640294
R5297 VDD.n1237 VDD.n1236 0.0640294
R5298 VDD VDD.n1247 0.0640294
R5299 VDD.n194 VDD.n173 0.0640294
R5300 VDD VDD.n189 0.0640294
R5301 VDD.n218 VDD.n217 0.0640294
R5302 VDD.n1252 VDD.n230 0.0640294
R5303 VDD VDD.n250 0.0640294
R5304 VDD.n323 VDD.n302 0.0640294
R5305 VDD VDD.n318 0.0640294
R5306 VDD.n1160 VDD.n278 0.0640294
R5307 VDD.n1180 VDD.n1179 0.0640294
R5308 VDD VDD.n1190 0.0640294
R5309 VDD VDD.n346 0.0640294
R5310 VDD.n356 VDD.n355 0.0640294
R5311 VDD.n1128 VDD.n372 0.0640294
R5312 VDD.n427 VDD.n405 0.0640294
R5313 VDD VDD.n425 0.0640294
R5314 VDD.n515 VDD.n487 0.0640294
R5315 VDD.n1109 VDD.n552 0.0640294
R5316 VDD VDD.n572 0.0640294
R5317 VDD.n538 VDD.n535 0.0640294
R5318 VDD VDD.n510 0.0640294
R5319 VDD VDD.n631 0.0640294
R5320 VDD.n1094 VDD.n1093 0.0640294
R5321 VDD VDD.n1104 0.0640294
R5322 VDD.n1075 VDD.n601 0.0640294
R5323 VDD VDD.n650 0.0640294
R5324 VDD.n686 VDD.n683 0.0640294
R5325 VDD.n754 VDD.n732 0.0640294
R5326 VDD VDD.n752 0.0640294
R5327 VDD.n1050 VDD.n703 0.0640294
R5328 VDD VDD.n676 0.0640294
R5329 VDD.n830 VDD.n808 0.0640294
R5330 VDD.n854 VDD.n851 0.0640294
R5331 VDD.n1028 VDD.n865 0.0640294
R5332 VDD VDD.n885 0.0640294
R5333 VDD VDD.n825 0.0640294
R5334 VDD.n955 VDD.n925 0.0640294
R5335 VDD.n964 VDD.n916 0.0640294
R5336 VDD.n978 VDD.n975 0.0640294
R5337 VDD.n998 VDD.n985 0.0640294
R5338 VDD.n1009 VDD.n1006 0.0640294
R5339 VDD.n1018 VDD.n1017 0.0640294
R5340 VDD VDD.n1081 0.0635
R5341 VDD.n1071 VDD 0.0635
R5342 VDD VDD.n769 0.0635
R5343 VDD.n1056 VDD 0.0635
R5344 VDD.n369 VDD 0.0631087
R5345 VDD.n465 VDD 0.0631087
R5346 VDD.n453 VDD 0.0631087
R5347 VDD.n444 VDD 0.0631087
R5348 VDD.n490 VDD 0.0631087
R5349 VDD.n606 VDD 0.0631087
R5350 VDD.n598 VDD 0.0631087
R5351 VDD.n691 VDD 0.0631087
R5352 VDD.n701 VDD 0.0631087
R5353 VDD.n802 VDD 0.0631087
R5354 VDD VDD.n1162 0.062
R5355 VDD VDD.n1070 0.0605
R5356 VDD VDD.n1069 0.05975
R5357 VDD.n94 VDD.n80 0.0587353
R5358 VDD.n1488 VDD.n71 0.0587353
R5359 VDD VDD.n1488 0.05825
R5360 VDD VDD.n1019 0.05525
R5361 VDD VDD.n1020 0.05525
R5362 VDD VDD.n1023 0.05525
R5363 VDD.n1005 VDD 0.05525
R5364 VDD.n1003 VDD 0.05525
R5365 VDD.n1000 VDD 0.05525
R5366 VDD.n997 VDD 0.05525
R5367 VDD.n994 VDD 0.05525
R5368 VDD VDD.n1522 0.0545
R5369 VDD VDD.n1492 0.0545
R5370 VDD.n1486 VDD 0.0545
R5371 VDD.n98 VDD 0.0545
R5372 VDD.n96 VDD 0.0545
R5373 VDD VDD.n1464 0.0545
R5374 VDD VDD.n1465 0.0545
R5375 VDD VDD.n1441 0.0545
R5376 VDD VDD.n1442 0.0545
R5377 VDD.n1435 VDD 0.0545
R5378 VDD VDD.n1395 0.0545
R5379 VDD VDD.n1396 0.0545
R5380 VDD VDD.n1318 0.0545
R5381 VDD VDD.n1319 0.0545
R5382 VDD.n1312 VDD 0.0545
R5383 VDD VDD.n1272 0.0545
R5384 VDD VDD.n1273 0.0545
R5385 VDD VDD.n126 0.0545
R5386 VDD VDD.n127 0.0545
R5387 VDD.n120 VDD 0.0545
R5388 VDD VDD.n215 0.0545
R5389 VDD VDD.n216 0.0545
R5390 VDD.n196 VDD 0.0545
R5391 VDD.n195 VDD 0.0545
R5392 VDD.n190 VDD 0.0545
R5393 VDD.n1163 VDD 0.0545
R5394 VDD.n1161 VDD 0.0545
R5395 VDD.n1152 VDD 0.0545
R5396 VDD.n325 VDD 0.0545
R5397 VDD.n324 VDD 0.0545
R5398 VDD.n319 VDD 0.0545
R5399 VDD VDD.n435 0.0545
R5400 VDD VDD.n440 0.0545
R5401 VDD VDD.n1132 0.0545
R5402 VDD VDD.n1133 0.0545
R5403 VDD VDD.n353 0.0545
R5404 VDD VDD.n354 0.0545
R5405 VDD.n347 VDD 0.0545
R5406 VDD VDD.n1113 0.0545
R5407 VDD VDD.n1115 0.0545
R5408 VDD.n525 VDD 0.0545
R5409 VDD.n516 VDD 0.0545
R5410 VDD.n511 VDD 0.0545
R5411 VDD.n1084 VDD 0.0545
R5412 VDD.n1083 VDD 0.0545
R5413 VDD VDD.n1075 0.0545
R5414 VDD.n1074 VDD 0.0545
R5415 VDD.n1068 VDD 0.0545
R5416 VDD.n651 VDD 0.0545
R5417 VDD VDD.n1048 0.0545
R5418 VDD VDD.n1052 0.0545
R5419 VDD VDD.n1062 0.0545
R5420 VDD VDD.n682 0.0545
R5421 VDD.n677 VDD 0.0545
R5422 VDD VDD.n1036 0.0545
R5423 VDD VDD.n1040 0.0545
R5424 VDD.n842 VDD 0.0545
R5425 VDD.n840 VDD 0.0545
R5426 VDD.n831 VDD 0.0545
R5427 VDD.n826 VDD 0.0545
R5428 VDD VDD.n1022 0.0545
R5429 VDD VDD.n887 0.0545
R5430 VDD.n1004 VDD 0.0545
R5431 VDD.n1001 VDD 0.0545
R5432 VDD.n999 VDD 0.0545
R5433 VDD.n995 VDD 0.0545
R5434 VDD.n992 VDD 0.0545
R5435 VDD VDD.n974 0.0545
R5436 VDD.n965 VDD 0.0545
R5437 VDD.n962 VDD 0.0545
R5438 VDD.n961 VDD 0.0545
R5439 VDD.n958 VDD 0.0545
R5440 VDD.n956 VDD 0.0545
R5441 VDD.n951 VDD 0.0545
R5442 VDD.n950 VDD 0.0545
R5443 VDD VDD.n95 0.05225
R5444 VDD.n1079 VDD 0.0515
R5445 VDD.n1052 VDD 0.0515
R5446 VDD VDD.n834 0.0515
R5447 VDD VDD.n1080 0.0485
R5448 VDD VDD.n1049 0.0485
R5449 VDD.n89 VDD 0.0481471
R5450 VDD.n12 VDD 0.0481471
R5451 VDD.n1430 VDD 0.0481471
R5452 VDD.n1558 VDD 0.0481471
R5453 VDD.n1307 VDD 0.0481471
R5454 VDD.n1372 VDD 0.0481471
R5455 VDD.n115 VDD 0.0481471
R5456 VDD.n1243 VDD 0.0481471
R5457 VDD.n185 VDD 0.0481471
R5458 VDD.n246 VDD 0.0481471
R5459 VDD.n314 VDD 0.0481471
R5460 VDD.n1186 VDD 0.0481471
R5461 VDD.n342 VDD 0.0481471
R5462 VDD.n421 VDD 0.0481471
R5463 VDD.n568 VDD 0.0481471
R5464 VDD.n506 VDD 0.0481471
R5465 VDD.n1100 VDD 0.0481471
R5466 VDD.n646 VDD 0.0481471
R5467 VDD.n748 VDD 0.0481471
R5468 VDD.n672 VDD 0.0481471
R5469 VDD.n881 VDD 0.0481471
R5470 VDD.n821 VDD 0.0481471
R5471 VDD.n933 VDD 0.0481471
R5472 VDD.n1013 VDD 0.0481471
R5473 VDD VDD.n770 0.047
R5474 VDD.n82 VDD 0.0455
R5475 VDD.n62 VDD 0.0455
R5476 VDD.n1494 VDD 0.0455
R5477 VDD.n1502 VDD 0.0455
R5478 VDD.n1568 VDD 0.0455
R5479 VDD.n1444 VDD 0.0455
R5480 VDD.n1458 VDD 0.0455
R5481 VDD.n1554 VDD 0.0455
R5482 VDD.n1321 VDD 0.0455
R5483 VDD.n1346 VDD 0.0455
R5484 VDD.n1368 VDD 0.0455
R5485 VDD.n129 VDD 0.0455
R5486 VDD.n1213 VDD 0.0455
R5487 VDD.n1239 VDD 0.0455
R5488 VDD.n179 VDD 0.0455
R5489 VDD.n220 VDD 0.0455
R5490 VDD.n242 VDD 0.0455
R5491 VDD.n308 VDD 0.0455
R5492 VDD.n288 VDD 0.0455
R5493 VDD.n1182 VDD 0.0455
R5494 VDD.n358 VDD 0.0455
R5495 VDD.n389 VDD 0.0455
R5496 VDD.n417 VDD 0.0455
R5497 VDD.n375 VDD 0.0455
R5498 VDD.n377 VDD 0.0455
R5499 VDD.n499 VDD 0.0455
R5500 VDD.n564 VDD 0.0455
R5501 VDD.n536 VDD 0.0455
R5502 VDD.n533 VDD 0.0455
R5503 VDD.n446 VDD 0.0455
R5504 VDD.n1067 VDD 0.0455
R5505 VDD VDD.n652 0.0455
R5506 VDD.n639 VDD 0.0455
R5507 VDD.n1096 VDD 0.0455
R5508 VDD.n616 VDD 0.0455
R5509 VDD.n636 VDD 0.0455
R5510 VDD.n634 VDD 0.0455
R5511 VDD.n684 VDD 0.0455
R5512 VDD.n744 VDD 0.0455
R5513 VDD.n717 VDD 0.0455
R5514 VDD.n815 VDD 0.0455
R5515 VDD.n852 VDD 0.0455
R5516 VDD.n877 VDD 0.0455
R5517 VDD.n942 VDD 0.0455
R5518 VDD.n936 VDD 0.0455
R5519 VDD.n976 VDD 0.0455
R5520 VDD.n981 VDD 0.0455
R5521 VDD.n1007 VDD 0.0455
R5522 VDD.n1131 VDD 0.0425
R5523 VDD.n1126 VDD 0.038
R5524 VDD VDD.n1043 0.038
R5525 VDD.n1044 VDD 0.038
R5526 VDD VDD.n473 0.0375588
R5527 VDD VDD.n545 0.0375588
R5528 VDD VDD.n613 0.0375588
R5529 VDD VDD.n593 0.0375588
R5530 VDD VDD.n697 0.0375588
R5531 VDD VDD.n793 0.0375588
R5532 VDD VDD.n516 0.0365
R5533 VDD VDD.n367 0.0357174
R5534 VDD VDD.n365 0.0357174
R5535 VDD VDD.n463 0.0357174
R5536 VDD VDD.n462 0.0357174
R5537 VDD VDD.n449 0.0357174
R5538 VDD VDD.n450 0.0357174
R5539 VDD VDD.n448 0.0357174
R5540 VDD VDD.n447 0.0357174
R5541 VDD VDD.n492 0.0357174
R5542 VDD VDD.n494 0.0357174
R5543 VDD VDD.n604 0.0357174
R5544 VDD VDD.n603 0.0357174
R5545 VDD VDD.n600 0.0357174
R5546 VDD VDD.n599 0.0357174
R5547 VDD VDD.n662 0.0357174
R5548 VDD VDD.n663 0.0357174
R5549 VDD VDD.n698 0.0357174
R5550 VDD VDD.n695 0.0357174
R5551 VDD VDD.n805 0.0357174
R5552 VDD VDD.n804 0.0357174
R5553 VDD.n1485 VDD.n98 0.0335
R5554 VDD VDD.n1130 0.0335
R5555 VDD.n1132 VDD 0.0335
R5556 VDD.n1119 VDD 0.0335
R5557 VDD.n1063 VDD.n657 0.0335
R5558 VDD.n957 VDD.n956 0.0335
R5559 VDD.n1489 VDD 0.03275
R5560 VDD.n80 VDD 0.0309412
R5561 VDD.n71 VDD 0.0309412
R5562 VDD.n473 VDD 0.0309412
R5563 VDD.n469 VDD 0.0309412
R5564 VDD VDD.n469 0.0309412
R5565 VDD.n456 VDD 0.0309412
R5566 VDD VDD.n456 0.0309412
R5567 VDD.n545 VDD 0.0309412
R5568 VDD.n613 VDD 0.0309412
R5569 VDD.n609 VDD 0.0309412
R5570 VDD VDD.n609 0.0309412
R5571 VDD.n596 VDD 0.0309412
R5572 VDD VDD.n596 0.0309412
R5573 VDD.n593 VDD 0.0309412
R5574 VDD.n693 VDD 0.0309412
R5575 VDD VDD.n693 0.0309412
R5576 VDD.n697 VDD 0.0309412
R5577 VDD.n799 VDD 0.0309412
R5578 VDD VDD.n799 0.0309412
R5579 VDD.n793 VDD 0.0309412
R5580 VDD VDD.n1523 0.0305
R5581 VDD.n1493 VDD 0.0305
R5582 VDD VDD.n1541 0.0305
R5583 VDD.n1475 VDD 0.0305
R5584 VDD.n1442 VDD 0.0305
R5585 VDD.n1387 VDD 0.0305
R5586 VDD.n1406 VDD 0.0305
R5587 VDD.n1319 VDD 0.0305
R5588 VDD VDD.n1226 0.0305
R5589 VDD.n1283 VDD 0.0305
R5590 VDD.n127 VDD 0.0305
R5591 VDD.n1261 VDD 0.0305
R5592 VDD VDD.n204 0.0305
R5593 VDD VDD.n195 0.0305
R5594 VDD VDD.n1169 0.0305
R5595 VDD VDD.n1165 0.0305
R5596 VDD VDD.n1163 0.0305
R5597 VDD VDD.n1151 0.0305
R5598 VDD VDD.n324 0.0305
R5599 VDD.n434 VDD 0.0305
R5600 VDD.n440 VDD 0.0305
R5601 VDD.n1134 VDD 0.0305
R5602 VDD.n354 VDD 0.0305
R5603 VDD VDD.n1116 0.0305
R5604 VDD.n1123 VDD.n1122 0.0305
R5605 VDD VDD.n525 0.0305
R5606 VDD VDD.n521 0.0305
R5607 VDD VDD.n1083 0.0305
R5608 VDD VDD.n1074 0.0305
R5609 VDD.n763 VDD 0.0305
R5610 VDD.n767 VDD 0.0305
R5611 VDD.n1037 VDD 0.0305
R5612 VDD.n1041 VDD 0.0305
R5613 VDD VDD.n842 0.0305
R5614 VDD VDD.n840 0.0305
R5615 VDD VDD.n369 0.0278913
R5616 VDD VDD.n465 0.0278913
R5617 VDD VDD.n453 0.0278913
R5618 VDD VDD.n444 0.0278913
R5619 VDD VDD.n490 0.0278913
R5620 VDD VDD.n606 0.0278913
R5621 VDD VDD.n598 0.0278913
R5622 VDD VDD.n691 0.0278913
R5623 VDD VDD.n701 0.0278913
R5624 VDD VDD.n802 0.0278913
R5625 VDD VDD.n1072 0.0275
R5626 VDD VDD.n1053 0.0275
R5627 VDD VDD.n439 0.0245
R5628 VDD.n1116 VDD 0.0245
R5629 VDD.n520 VDD 0.0245
R5630 VDD VDD.n1119 0.0215
R5631 VDD VDD.n529 0.0215
R5632 VDD VDD.n519 0.0215
R5633 VDD VDD.n1071 0.0215
R5634 VDD VDD.n1056 0.0215
R5635 VDD VDD.n1566 0.0185
R5636 VDD.n1563 VDD 0.0185
R5637 VDD VDD.n1377 0.0185
R5638 VDD.n1248 VDD 0.0185
R5639 VDD VDD.n1251 0.0185
R5640 VDD.n1191 VDD 0.0185
R5641 VDD VDD.n426 0.0185
R5642 VDD VDD.n1108 0.0185
R5643 VDD.n1120 VDD 0.0185
R5644 VDD.n1105 VDD 0.0185
R5645 VDD VDD.n753 0.0185
R5646 VDD VDD.n1027 0.0185
R5647 VDD VDD.n846 0.0155
R5648 VDD.n835 VDD 0.0125
R5649 VDD.n528 VDD 0.0095
R5650 VDD VDD.n1042 0.0095
R5651 VDD VDD.n838 0.0095
R5652 VDD.n1128 VDD 0.0065
R5653 VDD VDD.n1121 0.0065
R5654 VDD.n1080 VDD 0.0065
R5655 VDD.n1066 VDD 0.0035
R5656 VDD.n78 VDD 0.00182353
R5657 VDD.n69 VDD 0.00182353
R5658 VSS.n622 VSS 10545.3
R5659 VSS VSS.n621 10545.3
R5660 VSS.n2 VSS 10545.3
R5661 VSS.n574 VSS 10545.3
R5662 VSS VSS.n165 10294.7
R5663 VSS.n293 VSS.n138 7040.03
R5664 VSS.n631 VSS.n630 6185.08
R5665 VSS VSS.n272 5641.34
R5666 VSS.n135 VSS 5179.69
R5667 VSS.n163 VSS 5179.69
R5668 VSS.n630 VSS.n0 4791.81
R5669 VSS.n469 VSS.n0 4791.81
R5670 VSS.n469 VSS.n468 4791.81
R5671 VSS.n468 VSS.n464 4791.81
R5672 VSS.n464 VSS.n79 4791.81
R5673 VSS.n351 VSS.n79 4791.81
R5674 VSS.n352 VSS.n351 4791.81
R5675 VSS.n352 VSS.n347 4791.81
R5676 VSS.n347 VSS.n138 4791.81
R5677 VSS VSS.n233 4607.24
R5678 VSS.n236 VSS 3573.15
R5679 VSS.n598 VSS 2539.06
R5680 VSS VSS.n596 2539.06
R5681 VSS.n6 VSS 2539.06
R5682 VSS VSS.n529 2539.06
R5683 VSS VSS.n527 2539.06
R5684 VSS VSS.n526 2539.06
R5685 VSS VSS.n77 2539.06
R5686 VSS VSS.n24 2539.06
R5687 VSS VSS.n23 2539.06
R5688 VSS VSS.n56 2539.06
R5689 VSS VSS.n55 2539.06
R5690 VSS.n29 VSS 2539.06
R5691 VSS.n82 VSS 2539.06
R5692 VSS.n83 VSS 2539.06
R5693 VSS.n85 VSS 2539.06
R5694 VSS.n207 VSS 2539.06
R5695 VSS.n208 VSS 2539.06
R5696 VSS.n274 VSS 2539.06
R5697 VSS.n630 VSS.n629 2248.22
R5698 VSS.n531 VSS.n0 2248.22
R5699 VSS.n470 VSS.n469 2248.22
R5700 VSS.n468 VSS.n467 2248.22
R5701 VSS.n464 VSS.n463 2248.22
R5702 VSS.n377 VSS.n79 2248.22
R5703 VSS.n351 VSS.n350 2248.22
R5704 VSS.n353 VSS.n352 2248.22
R5705 VSS.n347 VSS.n346 2248.22
R5706 VSS.n144 VSS.n138 2248.22
R5707 VSS.n134 VSS 2077.41
R5708 VSS.n236 VSS 2077.41
R5709 VSS.n292 VSS 2077.41
R5710 VSS.n151 VSS 1526.04
R5711 VSS VSS.n206 1504.97
R5712 VSS VSS.n234 1504.97
R5713 VSS VSS.n291 1504.97
R5714 VSS.n167 VSS 1080.26
R5715 VSS VSS.n135 1024.86
R5716 VSS VSS.n134 1024.86
R5717 VSS VSS.n163 1024.86
R5718 VSS.n149 VSS 1024.86
R5719 VSS.n8 VSS 1008.99
R5720 VSS.n519 VSS 1008.99
R5721 VSS.n16 VSS 1008.99
R5722 VSS.n31 VSS 1008.99
R5723 VSS.n87 VSS 1008.99
R5724 VSS.n95 VSS 1008.99
R5725 VSS.n109 VSS 1008.99
R5726 VSS.n159 VSS 1008.99
R5727 VSS.n200 VSS 1008.99
R5728 VSS.n228 VSS 1008.99
R5729 VSS.n597 VSS 987.927
R5730 VSS.n7 VSS 987.927
R5731 VSS VSS.n530 987.927
R5732 VSS VSS.n525 987.927
R5733 VSS VSS.n78 987.927
R5734 VSS VSS.n22 987.927
R5735 VSS VSS.n57 987.927
R5736 VSS.n30 VSS 987.927
R5737 VSS.n80 VSS 987.927
R5738 VSS.n86 VSS 987.927
R5739 VSS VSS.n376 987.927
R5740 VSS VSS.n375 987.927
R5741 VSS VSS.n103 987.927
R5742 VSS VSS.n102 987.927
R5743 VSS VSS.n101 987.927
R5744 VSS VSS.n136 987.927
R5745 VSS.n107 VSS 987.927
R5746 VSS.n108 VSS 987.927
R5747 VSS.n166 VSS 987.927
R5748 VSS.n167 VSS 987.927
R5749 VSS VSS.n164 987.927
R5750 VSS.n139 VSS 987.927
R5751 VSS VSS.n205 987.927
R5752 VSS VSS.n143 987.927
R5753 VSS.n235 VSS 987.927
R5754 VSS VSS.n292 987.927
R5755 VSS.n150 VSS 987.927
R5756 VSS VSS.n573 612.236
R5757 VSS.n629 VSS 581.677
R5758 VSS.n531 VSS 581.677
R5759 VSS.n470 VSS 581.677
R5760 VSS.n467 VSS 581.677
R5761 VSS.n463 VSS 581.677
R5762 VSS.n377 VSS 581.677
R5763 VSS.n350 VSS 581.677
R5764 VSS.n353 VSS 581.677
R5765 VSS.n346 VSS 581.677
R5766 VSS.n144 VSS 581.677
R5767 VSS.n293 VSS 581.677
R5768 VSS VSS.n597 563.211
R5769 VSS.n598 VSS 563.211
R5770 VSS.n596 VSS 563.211
R5771 VSS VSS.n6 563.211
R5772 VSS VSS.n7 563.211
R5773 VSS.n530 VSS 563.211
R5774 VSS.n529 VSS 563.211
R5775 VSS.n527 VSS 563.211
R5776 VSS.n526 VSS 563.211
R5777 VSS.n525 VSS 563.211
R5778 VSS.n78 VSS 563.211
R5779 VSS.n77 VSS 563.211
R5780 VSS.n24 VSS 563.211
R5781 VSS.n23 VSS 563.211
R5782 VSS.n22 VSS 563.211
R5783 VSS.n57 VSS 563.211
R5784 VSS.n56 VSS 563.211
R5785 VSS.n55 VSS 563.211
R5786 VSS VSS.n29 563.211
R5787 VSS VSS.n30 563.211
R5788 VSS VSS.n80 563.211
R5789 VSS VSS.n82 563.211
R5790 VSS VSS.n83 563.211
R5791 VSS VSS.n85 563.211
R5792 VSS VSS.n86 563.211
R5793 VSS.n376 VSS 563.211
R5794 VSS.n375 VSS 563.211
R5795 VSS.n103 VSS 563.211
R5796 VSS.n102 VSS 563.211
R5797 VSS.n101 VSS 563.211
R5798 VSS.n136 VSS 563.211
R5799 VSS VSS.n108 563.211
R5800 VSS VSS.n166 563.211
R5801 VSS.n165 VSS 563.211
R5802 VSS VSS.n139 563.211
R5803 VSS VSS.n207 563.211
R5804 VSS.n208 VSS 563.211
R5805 VSS.n206 VSS 563.211
R5806 VSS VSS.n143 563.211
R5807 VSS VSS.n235 563.211
R5808 VSS.n234 VSS 563.211
R5809 VSS.n233 VSS 563.211
R5810 VSS.n291 VSS 563.211
R5811 VSS VSS.n273 563.211
R5812 VSS.n274 VSS 563.211
R5813 VSS.n272 VSS 563.211
R5814 VSS VSS.n149 563.211
R5815 VSS VSS.n150 563.211
R5816 VSS VSS.n107 526.279
R5817 VSS.n273 VSS 470.882
R5818 VSS.n631 VSS 360.476
R5819 VSS.n622 VSS 349.033
R5820 VSS.n621 VSS 349.033
R5821 VSS VSS.n2 349.033
R5822 VSS.n574 VSS 349.033
R5823 VSS.n573 VSS 349.033
R5824 VSS.n205 VSS 46.1653
R5825 VSS.n164 VSS 9.23345
R5826 VSS VSS.n631 5.32226
R5827 VSS.n597 VSS 5.32226
R5828 VSS.n596 VSS 5.32226
R5829 VSS VSS.n7 5.32226
R5830 VSS.n78 VSS 5.32226
R5831 VSS VSS.n24 5.32226
R5832 VSS.n22 VSS 5.32226
R5833 VSS VSS.n80 5.32226
R5834 VSS VSS.n83 5.32226
R5835 VSS VSS.n86 5.32226
R5836 VSS.n376 VSS 5.32226
R5837 VSS VSS.n103 5.32226
R5838 VSS.n101 VSS 5.32226
R5839 VSS VSS.n136 5.32226
R5840 VSS.n134 VSS 5.32226
R5841 VSS VSS.n108 5.32226
R5842 VSS.n166 VSS 5.32226
R5843 VSS VSS.n165 5.32226
R5844 VSS.n163 VSS 5.32226
R5845 VSS.n205 VSS 5.32226
R5846 VSS VSS.n139 5.32226
R5847 VSS VSS.n208 5.32226
R5848 VSS VSS.n143 5.32226
R5849 VSS VSS.n236 5.32226
R5850 VSS.n233 VSS 5.32226
R5851 VSS VSS.n292 5.32226
R5852 VSS.n291 VSS 5.32226
R5853 VSS VSS.n274 5.32226
R5854 VSS.n272 VSS 5.32226
R5855 VSS VSS.n150 5.32226
R5856 VSS VSS.n30 5.32226
R5857 VSS.n55 VSS 5.32226
R5858 VSS VSS.n57 5.32226
R5859 VSS.n525 VSS 5.32226
R5860 VSS VSS.n527 5.32226
R5861 VSS VSS.n530 5.32226
R5862 VSS VSS.n573 5.32226
R5863 VSS VSS.n574 5.32226
R5864 VSS VSS.n2 5.32226
R5865 VSS.n621 VSS 5.32226
R5866 VSS VSS.n622 5.32226
R5867 VSS.n599 VSS.n598 5.2005
R5868 VSS.n6 VSS.n5 5.2005
R5869 VSS.n526 VSS.n518 5.2005
R5870 VSS.n529 VSS.n528 5.2005
R5871 VSS.n77 VSS.n76 5.2005
R5872 VSS.n23 VSS.n15 5.2005
R5873 VSS.n29 VSS.n28 5.2005
R5874 VSS.n56 VSS.n27 5.2005
R5875 VSS.n82 VSS.n81 5.2005
R5876 VSS.n85 VSS.n84 5.2005
R5877 VSS.n375 VSS.n374 5.2005
R5878 VSS.n102 VSS.n94 5.2005
R5879 VSS.n135 VSS.n105 5.2005
R5880 VSS.n107 VSS.n106 5.2005
R5881 VSS.n168 VSS.n167 5.2005
R5882 VSS.n164 VSS.n158 5.2005
R5883 VSS.n207 VSS.n140 5.2005
R5884 VSS.n206 VSS.n199 5.2005
R5885 VSS.n235 VSS.n142 5.2005
R5886 VSS.n234 VSS.n227 5.2005
R5887 VSS.n273 VSS.n147 5.2005
R5888 VSS.n149 VSS.n148 5.2005
R5889 VSS.n305 VSS.n304 4.9415
R5890 VSS.n323 VSS.n141 4.9415
R5891 VSS.n255 VSS.n254 4.9415
R5892 VSS.n306 VSS.n305 4.5005
R5893 VSS.n343 VSS.n137 4.5005
R5894 VSS.n357 VSS.n356 4.5005
R5895 VSS.n383 VSS.n382 4.5005
R5896 VSS.n381 VSS.n380 4.5005
R5897 VSS.n460 VSS.n58 4.5005
R5898 VSS.n476 VSS.n475 4.5005
R5899 VSS.n474 VSS.n473 4.5005
R5900 VSS.n534 VSS.n1 4.5005
R5901 VSS.n626 VSS.n625 4.5005
R5902 VSS.n624 VSS.n623 4.5005
R5903 VSS.n576 VSS.n575 4.5005
R5904 VSS.n620 VSS.n619 4.5005
R5905 VSS.n578 VSS.n577 4.5005
R5906 VSS.n618 VSS.n617 4.5005
R5907 VSS.n323 VSS.n322 4.5005
R5908 VSS.n325 VSS.n324 4.5005
R5909 VSS.n186 VSS.n104 4.5005
R5910 VSS.n400 VSS.n399 4.5005
R5911 VSS.n402 VSS.n401 4.5005
R5912 VSS.n442 VSS.n25 4.5005
R5913 VSS.n495 VSS.n494 4.5005
R5914 VSS.n497 VSS.n496 4.5005
R5915 VSS.n552 VSS.n3 4.5005
R5916 VSS.n572 VSS.n571 4.5005
R5917 VSS.n517 VSS.n516 4.5005
R5918 VSS.n254 VSS.n253 4.5005
R5919 VSS.n226 VSS.n225 4.5005
R5920 VSS.n198 VSS.n197 4.5005
R5921 VSS.n115 VSS.n93 4.5005
R5922 VSS.n421 VSS.n420 4.5005
R5923 VSS.n423 VSS.n422 4.5005
R5924 VSS.n37 VSS.n14 4.5005
R5925 VSS.n629 VSS.n628 2.60068
R5926 VSS.n532 VSS.n531 2.60068
R5927 VSS.n471 VSS.n470 2.60068
R5928 VSS.n467 VSS.n466 2.60068
R5929 VSS.n463 VSS.n462 2.60068
R5930 VSS.n378 VSS.n377 2.60068
R5931 VSS.n350 VSS.n349 2.60068
R5932 VSS.n354 VSS.n353 2.60068
R5933 VSS.n346 VSS.n345 2.60068
R5934 VSS.n145 VSS.n144 2.60068
R5935 VSS.n294 VSS.n293 2.60068
R5936 VSS.n625 VSS.n624 0.4415
R5937 VSS.n625 VSS.n1 0.4415
R5938 VSS.n474 VSS.n1 0.4415
R5939 VSS.n475 VSS.n474 0.4415
R5940 VSS.n475 VSS.n58 0.4415
R5941 VSS.n381 VSS.n58 0.4415
R5942 VSS.n382 VSS.n381 0.4415
R5943 VSS.n382 VSS.n357 0.4415
R5944 VSS.n357 VSS.n137 0.4415
R5945 VSS.n305 VSS.n137 0.4415
R5946 VSS.n619 VSS.n618 0.4415
R5947 VSS.n618 VSS.n3 0.4415
R5948 VSS.n496 VSS.n3 0.4415
R5949 VSS.n496 VSS.n495 0.4415
R5950 VSS.n495 VSS.n25 0.4415
R5951 VSS.n401 VSS.n25 0.4415
R5952 VSS.n401 VSS.n400 0.4415
R5953 VSS.n400 VSS.n104 0.4415
R5954 VSS.n324 VSS.n104 0.4415
R5955 VSS.n324 VSS.n323 0.4415
R5956 VSS.n577 VSS.n576 0.4415
R5957 VSS.n577 VSS.n572 0.4415
R5958 VSS.n572 VSS.n517 0.4415
R5959 VSS.n517 VSS.n14 0.4415
R5960 VSS.n422 VSS.n14 0.4415
R5961 VSS.n422 VSS.n421 0.4415
R5962 VSS.n421 VSS.n93 0.4415
R5963 VSS.n198 VSS.n93 0.4415
R5964 VSS.n226 VSS.n198 0.4415
R5965 VSS.n254 VSS.n226 0.4415
R5966 VSS.n359 VSS 0.337022
R5967 VSS.n129 VSS 0.337022
R5968 VSS.n176 VSS 0.337022
R5969 VSS.n211 VSS 0.337022
R5970 VSS.n329 VSS 0.337022
R5971 VSS.n248 VSS 0.337022
R5972 VSS.n192 VSS.n191 0.3365
R5973 VSS.n250 VSS.n249 0.3365
R5974 VSS.n9 VSS 0.311587
R5975 VSS.n588 VSS 0.311587
R5976 VSS.n607 VSS 0.311587
R5977 VSS.n520 VSS 0.311587
R5978 VSS.n17 VSS 0.311587
R5979 VSS.n506 VSS 0.311587
R5980 VSS.n74 VSS 0.311587
R5981 VSS.n32 VSS 0.311587
R5982 VSS.n88 VSS 0.311587
R5983 VSS.n433 VSS 0.311587
R5984 VSS.n452 VSS 0.311587
R5985 VSS.n96 VSS 0.311587
R5986 VSS.n410 VSS 0.311587
R5987 VSS.n373 VSS 0.311587
R5988 VSS.n110 VSS 0.311587
R5989 VSS.n125 VSS 0.311587
R5990 VSS.n395 VSS 0.311587
R5991 VSS.n389 VSS 0.311587
R5992 VSS.n193 VSS 0.311587
R5993 VSS.n180 VSS 0.311587
R5994 VSS.n210 VSS 0.311587
R5995 VSS.n335 VSS 0.311587
R5996 VSS.n246 VSS 0.311587
R5997 VSS.n314 VSS 0.311587
R5998 VSS.n290 VSS 0.311587
R5999 VSS.n47 VSS 0.311587
R6000 VSS.n484 VSS 0.311587
R6001 VSS.n561 VSS 0.311587
R6002 VSS.n542 VSS 0.311587
R6003 VSS.n360 VSS 0.307674
R6004 VSS.n361 VSS 0.307674
R6005 VSS.n126 VSS 0.307674
R6006 VSS.n128 VSS 0.307674
R6007 VSS.n388 VSS 0.307674
R6008 VSS.n387 VSS 0.307674
R6009 VSS.n201 VSS 0.307674
R6010 VSS.n202 VSS 0.307674
R6011 VSS.n229 VSS 0.307674
R6012 VSS.n230 VSS 0.307674
R6013 VSS.n271 VSS 0.307674
R6014 VSS.n270 VSS 0.307674
R6015 VSS.n10 VSS 0.301804
R6016 VSS.n11 VSS 0.301804
R6017 VSS.n12 VSS 0.301804
R6018 VSS.n13 VSS 0.301804
R6019 VSS.n521 VSS 0.301804
R6020 VSS.n522 VSS 0.301804
R6021 VSS.n523 VSS 0.301804
R6022 VSS.n524 VSS 0.301804
R6023 VSS.n18 VSS 0.301804
R6024 VSS.n19 VSS 0.301804
R6025 VSS.n20 VSS 0.301804
R6026 VSS.n21 VSS 0.301804
R6027 VSS.n33 VSS 0.301804
R6028 VSS.n34 VSS 0.301804
R6029 VSS.n35 VSS 0.301804
R6030 VSS.n36 VSS 0.301804
R6031 VSS.n89 VSS 0.301804
R6032 VSS.n90 VSS 0.301804
R6033 VSS.n91 VSS 0.301804
R6034 VSS.n92 VSS 0.301804
R6035 VSS.n97 VSS 0.301804
R6036 VSS.n98 VSS 0.301804
R6037 VSS.n99 VSS 0.301804
R6038 VSS.n100 VSS 0.301804
R6039 VSS.n362 VSS 0.301804
R6040 VSS.n363 VSS 0.301804
R6041 VSS.n364 VSS 0.301804
R6042 VSS.n365 VSS 0.301804
R6043 VSS.n111 VSS 0.301804
R6044 VSS.n112 VSS 0.301804
R6045 VSS.n113 VSS 0.301804
R6046 VSS.n114 VSS 0.301804
R6047 VSS.n386 VSS 0.301804
R6048 VSS.n385 VSS 0.301804
R6049 VSS.n384 VSS 0.301804
R6050 VSS.n348 VSS 0.301804
R6051 VSS.n209 VSS 0.301804
R6052 VSS.n326 VSS 0.301804
R6053 VSS.n327 VSS 0.301804
R6054 VSS.n328 VSS 0.301804
R6055 VSS.n330 VSS 0.301804
R6056 VSS.n331 VSS 0.301804
R6057 VSS.n332 VSS 0.301804
R6058 VSS.n333 VSS 0.301804
R6059 VSS.n244 VSS 0.301804
R6060 VSS.n243 VSS 0.301804
R6061 VSS.n242 VSS 0.301804
R6062 VSS.n241 VSS 0.301804
R6063 VSS.n319 VSS 0.301804
R6064 VSS.n318 VSS 0.301804
R6065 VSS.n317 VSS 0.301804
R6066 VSS.n316 VSS 0.301804
R6067 VSS.n269 VSS 0.301804
R6068 VSS.n268 VSS 0.301804
R6069 VSS.n267 VSS 0.301804
R6070 VSS.n266 VSS 0.301804
R6071 VSS.n278 VSS 0.301804
R6072 VSS.n279 VSS 0.301804
R6073 VSS.n280 VSS 0.301804
R6074 VSS.n281 VSS 0.301804
R6075 VSS.n589 VSS 0.295935
R6076 VSS.n590 VSS 0.295935
R6077 VSS.n591 VSS 0.295935
R6078 VSS.n592 VSS 0.295935
R6079 VSS.n593 VSS 0.295935
R6080 VSS.n594 VSS 0.295935
R6081 VSS.n595 VSS 0.295935
R6082 VSS.n4 VSS 0.295935
R6083 VSS.n616 VSS 0.295935
R6084 VSS.n615 VSS 0.295935
R6085 VSS.n614 VSS 0.295935
R6086 VSS.n613 VSS 0.295935
R6087 VSS.n612 VSS 0.295935
R6088 VSS.n611 VSS 0.295935
R6089 VSS.n610 VSS 0.295935
R6090 VSS.n609 VSS 0.295935
R6091 VSS.n606 VSS 0.295935
R6092 VSS.n605 VSS 0.295935
R6093 VSS.n604 VSS 0.295935
R6094 VSS.n603 VSS 0.295935
R6095 VSS.n602 VSS 0.295935
R6096 VSS.n601 VSS 0.295935
R6097 VSS.n600 VSS 0.295935
R6098 VSS.n627 VSS 0.295935
R6099 VSS.n505 VSS 0.295935
R6100 VSS.n504 VSS 0.295935
R6101 VSS.n503 VSS 0.295935
R6102 VSS.n502 VSS 0.295935
R6103 VSS.n501 VSS 0.295935
R6104 VSS.n500 VSS 0.295935
R6105 VSS.n499 VSS 0.295935
R6106 VSS.n498 VSS 0.295935
R6107 VSS.n59 VSS 0.295935
R6108 VSS.n60 VSS 0.295935
R6109 VSS.n61 VSS 0.295935
R6110 VSS.n62 VSS 0.295935
R6111 VSS.n63 VSS 0.295935
R6112 VSS.n64 VSS 0.295935
R6113 VSS.n65 VSS 0.295935
R6114 VSS.n66 VSS 0.295935
R6115 VSS.n73 VSS 0.295935
R6116 VSS.n72 VSS 0.295935
R6117 VSS.n71 VSS 0.295935
R6118 VSS.n70 VSS 0.295935
R6119 VSS.n69 VSS 0.295935
R6120 VSS.n68 VSS 0.295935
R6121 VSS.n67 VSS 0.295935
R6122 VSS.n472 VSS 0.295935
R6123 VSS.n434 VSS 0.295935
R6124 VSS.n435 VSS 0.295935
R6125 VSS.n436 VSS 0.295935
R6126 VSS.n437 VSS 0.295935
R6127 VSS.n438 VSS 0.295935
R6128 VSS.n439 VSS 0.295935
R6129 VSS.n440 VSS 0.295935
R6130 VSS.n441 VSS 0.295935
R6131 VSS.n443 VSS 0.295935
R6132 VSS.n444 VSS 0.295935
R6133 VSS.n445 VSS 0.295935
R6134 VSS.n446 VSS 0.295935
R6135 VSS.n447 VSS 0.295935
R6136 VSS.n448 VSS 0.295935
R6137 VSS.n449 VSS 0.295935
R6138 VSS.n450 VSS 0.295935
R6139 VSS.n453 VSS 0.295935
R6140 VSS.n454 VSS 0.295935
R6141 VSS.n455 VSS 0.295935
R6142 VSS.n456 VSS 0.295935
R6143 VSS.n457 VSS 0.295935
R6144 VSS.n458 VSS 0.295935
R6145 VSS.n459 VSS 0.295935
R6146 VSS.n461 VSS 0.295935
R6147 VSS.n372 VSS 0.295935
R6148 VSS.n371 VSS 0.295935
R6149 VSS.n370 VSS 0.295935
R6150 VSS.n369 VSS 0.295935
R6151 VSS.n368 VSS 0.295935
R6152 VSS.n367 VSS 0.295935
R6153 VSS.n366 VSS 0.295935
R6154 VSS.n379 VSS 0.295935
R6155 VSS.n175 VSS 0.295935
R6156 VSS.n174 VSS 0.295935
R6157 VSS.n173 VSS 0.295935
R6158 VSS.n172 VSS 0.295935
R6159 VSS.n171 VSS 0.295935
R6160 VSS.n170 VSS 0.295935
R6161 VSS.n169 VSS 0.295935
R6162 VSS.n355 VSS 0.295935
R6163 VSS.n336 VSS 0.295935
R6164 VSS.n337 VSS 0.295935
R6165 VSS.n338 VSS 0.295935
R6166 VSS.n339 VSS 0.295935
R6167 VSS.n340 VSS 0.295935
R6168 VSS.n341 VSS 0.295935
R6169 VSS.n342 VSS 0.295935
R6170 VSS.n344 VSS 0.295935
R6171 VSS.n313 VSS 0.295935
R6172 VSS.n312 VSS 0.295935
R6173 VSS.n311 VSS 0.295935
R6174 VSS.n310 VSS 0.295935
R6175 VSS.n309 VSS 0.295935
R6176 VSS.n308 VSS 0.295935
R6177 VSS.n307 VSS 0.295935
R6178 VSS.n146 VSS 0.295935
R6179 VSS.n289 VSS 0.295935
R6180 VSS.n288 VSS 0.295935
R6181 VSS.n287 VSS 0.295935
R6182 VSS.n286 VSS 0.295935
R6183 VSS.n285 VSS 0.295935
R6184 VSS.n284 VSS 0.295935
R6185 VSS.n283 VSS 0.295935
R6186 VSS.n303 VSS 0.295935
R6187 VSS.n302 VSS 0.295935
R6188 VSS.n301 VSS 0.295935
R6189 VSS.n300 VSS 0.295935
R6190 VSS.n299 VSS 0.295935
R6191 VSS.n298 VSS 0.295935
R6192 VSS.n297 VSS 0.295935
R6193 VSS.n296 VSS 0.295935
R6194 VSS.n295 VSS 0.295935
R6195 VSS.n48 VSS 0.295935
R6196 VSS.n49 VSS 0.295935
R6197 VSS.n50 VSS 0.295935
R6198 VSS.n51 VSS 0.295935
R6199 VSS.n52 VSS 0.295935
R6200 VSS.n53 VSS 0.295935
R6201 VSS.n54 VSS 0.295935
R6202 VSS.n26 VSS 0.295935
R6203 VSS.n493 VSS 0.295935
R6204 VSS.n492 VSS 0.295935
R6205 VSS.n491 VSS 0.295935
R6206 VSS.n490 VSS 0.295935
R6207 VSS.n489 VSS 0.295935
R6208 VSS.n488 VSS 0.295935
R6209 VSS.n487 VSS 0.295935
R6210 VSS.n486 VSS 0.295935
R6211 VSS.n483 VSS 0.295935
R6212 VSS.n482 VSS 0.295935
R6213 VSS.n481 VSS 0.295935
R6214 VSS.n480 VSS 0.295935
R6215 VSS.n479 VSS 0.295935
R6216 VSS.n478 VSS 0.295935
R6217 VSS.n477 VSS 0.295935
R6218 VSS.n465 VSS 0.295935
R6219 VSS.n560 VSS 0.295935
R6220 VSS.n559 VSS 0.295935
R6221 VSS.n558 VSS 0.295935
R6222 VSS.n557 VSS 0.295935
R6223 VSS.n556 VSS 0.295935
R6224 VSS.n555 VSS 0.295935
R6225 VSS.n554 VSS 0.295935
R6226 VSS.n553 VSS 0.295935
R6227 VSS.n551 VSS 0.295935
R6228 VSS.n550 VSS 0.295935
R6229 VSS.n549 VSS 0.295935
R6230 VSS.n548 VSS 0.295935
R6231 VSS.n547 VSS 0.295935
R6232 VSS.n546 VSS 0.295935
R6233 VSS.n545 VSS 0.295935
R6234 VSS.n544 VSS 0.295935
R6235 VSS.n541 VSS 0.295935
R6236 VSS.n540 VSS 0.295935
R6237 VSS.n539 VSS 0.295935
R6238 VSS.n538 VSS 0.295935
R6239 VSS.n537 VSS 0.295935
R6240 VSS.n536 VSS 0.295935
R6241 VSS.n535 VSS 0.295935
R6242 VSS.n533 VSS 0.295935
R6243 VSS.n579 VSS 0.292022
R6244 VSS.n580 VSS 0.292022
R6245 VSS.n581 VSS 0.292022
R6246 VSS.n582 VSS 0.292022
R6247 VSS.n583 VSS 0.292022
R6248 VSS.n584 VSS 0.292022
R6249 VSS.n585 VSS 0.292022
R6250 VSS.n586 VSS 0.292022
R6251 VSS.n570 VSS 0.292022
R6252 VSS.n569 VSS 0.292022
R6253 VSS.n568 VSS 0.292022
R6254 VSS.n567 VSS 0.292022
R6255 VSS.n566 VSS 0.292022
R6256 VSS.n565 VSS 0.292022
R6257 VSS.n564 VSS 0.292022
R6258 VSS.n563 VSS 0.292022
R6259 VSS.n515 VSS 0.292022
R6260 VSS.n514 VSS 0.292022
R6261 VSS.n513 VSS 0.292022
R6262 VSS.n512 VSS 0.292022
R6263 VSS.n511 VSS 0.292022
R6264 VSS.n510 VSS 0.292022
R6265 VSS.n509 VSS 0.292022
R6266 VSS.n508 VSS 0.292022
R6267 VSS.n38 VSS 0.292022
R6268 VSS.n39 VSS 0.292022
R6269 VSS.n40 VSS 0.292022
R6270 VSS.n41 VSS 0.292022
R6271 VSS.n42 VSS 0.292022
R6272 VSS.n43 VSS 0.292022
R6273 VSS.n44 VSS 0.292022
R6274 VSS.n45 VSS 0.292022
R6275 VSS.n424 VSS 0.292022
R6276 VSS.n425 VSS 0.292022
R6277 VSS.n426 VSS 0.292022
R6278 VSS.n427 VSS 0.292022
R6279 VSS.n428 VSS 0.292022
R6280 VSS.n429 VSS 0.292022
R6281 VSS.n430 VSS 0.292022
R6282 VSS.n431 VSS 0.292022
R6283 VSS.n419 VSS 0.292022
R6284 VSS.n418 VSS 0.292022
R6285 VSS.n417 VSS 0.292022
R6286 VSS.n416 VSS 0.292022
R6287 VSS.n415 VSS 0.292022
R6288 VSS.n414 VSS 0.292022
R6289 VSS.n413 VSS 0.292022
R6290 VSS.n412 VSS 0.292022
R6291 VSS.n409 VSS 0.292022
R6292 VSS.n408 VSS 0.292022
R6293 VSS.n407 VSS 0.292022
R6294 VSS.n406 VSS 0.292022
R6295 VSS.n405 VSS 0.292022
R6296 VSS.n404 VSS 0.292022
R6297 VSS.n403 VSS 0.292022
R6298 VSS.n358 VSS 0.292022
R6299 VSS.n116 VSS 0.292022
R6300 VSS.n117 VSS 0.292022
R6301 VSS.n118 VSS 0.292022
R6302 VSS.n119 VSS 0.292022
R6303 VSS.n120 VSS 0.292022
R6304 VSS.n121 VSS 0.292022
R6305 VSS.n122 VSS 0.292022
R6306 VSS.n123 VSS 0.292022
R6307 VSS.n224 VSS 0.292022
R6308 VSS.n223 VSS 0.292022
R6309 VSS.n222 VSS 0.292022
R6310 VSS.n221 VSS 0.292022
R6311 VSS.n220 VSS 0.292022
R6312 VSS.n219 VSS 0.292022
R6313 VSS.n218 VSS 0.292022
R6314 VSS.n217 VSS 0.292022
R6315 VSS.n231 VSS 0.292022
R6316 VSS.n232 VSS 0.292022
R6317 VSS.n252 VSS 0.292022
R6318 VSS.n251 VSS 0.292022
R6319 VSS.n250 VSS 0.292022
R6320 VSS.n249 VSS 0.292022
R6321 VSS.n152 VSS 0.292022
R6322 VSS.n153 VSS 0.292022
R6323 VSS.n154 VSS 0.292022
R6324 VSS.n155 VSS 0.292022
R6325 VSS.n156 VSS 0.292022
R6326 VSS.n256 VSS 0.292022
R6327 VSS.n257 VSS 0.292022
R6328 VSS.n258 VSS 0.292022
R6329 VSS VSS.n183 0.2915
R6330 VSS VSS.n185 0.2915
R6331 VSS.n359 VSS 0.2825
R6332 VSS.n129 VSS 0.2825
R6333 VSS.n126 VSS 0.2825
R6334 VSS VSS.n180 0.2825
R6335 VSS VSS.n182 0.2825
R6336 VSS VSS.n329 0.2825
R6337 VSS.n212 VSS 0.2825
R6338 VSS VSS.n246 0.2825
R6339 VSS.n247 VSS 0.2705
R6340 VSS.n392 VSS 0.254
R6341 VSS VSS.n192 0.254
R6342 VSS VSS.n600 0.2525
R6343 VSS VSS.n601 0.2525
R6344 VSS VSS.n602 0.2525
R6345 VSS VSS.n603 0.2525
R6346 VSS VSS.n604 0.2525
R6347 VSS VSS.n605 0.2525
R6348 VSS VSS.n606 0.2525
R6349 VSS VSS.n607 0.2525
R6350 VSS.n610 VSS 0.2525
R6351 VSS.n611 VSS 0.2525
R6352 VSS.n612 VSS 0.2525
R6353 VSS.n613 VSS 0.2525
R6354 VSS.n614 VSS 0.2525
R6355 VSS.n615 VSS 0.2525
R6356 VSS.n616 VSS 0.2525
R6357 VSS.n595 VSS 0.2525
R6358 VSS.n594 VSS 0.2525
R6359 VSS.n593 VSS 0.2525
R6360 VSS.n592 VSS 0.2525
R6361 VSS.n591 VSS 0.2525
R6362 VSS.n590 VSS 0.2525
R6363 VSS.n589 VSS 0.2525
R6364 VSS.n588 VSS 0.2525
R6365 VSS VSS.n585 0.2525
R6366 VSS VSS.n584 0.2525
R6367 VSS VSS.n583 0.2525
R6368 VSS VSS.n582 0.2525
R6369 VSS VSS.n581 0.2525
R6370 VSS VSS.n580 0.2525
R6371 VSS VSS.n579 0.2525
R6372 VSS.n12 VSS 0.2525
R6373 VSS.n11 VSS 0.2525
R6374 VSS.n10 VSS 0.2525
R6375 VSS VSS.n535 0.2525
R6376 VSS VSS.n536 0.2525
R6377 VSS VSS.n537 0.2525
R6378 VSS VSS.n538 0.2525
R6379 VSS VSS.n539 0.2525
R6380 VSS VSS.n540 0.2525
R6381 VSS VSS.n541 0.2525
R6382 VSS VSS.n542 0.2525
R6383 VSS.n545 VSS 0.2525
R6384 VSS.n546 VSS 0.2525
R6385 VSS.n547 VSS 0.2525
R6386 VSS.n548 VSS 0.2525
R6387 VSS.n549 VSS 0.2525
R6388 VSS.n550 VSS 0.2525
R6389 VSS.n551 VSS 0.2525
R6390 VSS VSS.n554 0.2525
R6391 VSS VSS.n555 0.2525
R6392 VSS VSS.n556 0.2525
R6393 VSS VSS.n557 0.2525
R6394 VSS VSS.n558 0.2525
R6395 VSS VSS.n559 0.2525
R6396 VSS VSS.n560 0.2525
R6397 VSS VSS.n561 0.2525
R6398 VSS.n564 VSS 0.2525
R6399 VSS.n565 VSS 0.2525
R6400 VSS.n566 VSS 0.2525
R6401 VSS.n567 VSS 0.2525
R6402 VSS.n568 VSS 0.2525
R6403 VSS.n569 VSS 0.2525
R6404 VSS.n570 VSS 0.2525
R6405 VSS.n523 VSS 0.2525
R6406 VSS.n522 VSS 0.2525
R6407 VSS.n521 VSS 0.2525
R6408 VSS VSS.n67 0.2525
R6409 VSS VSS.n68 0.2525
R6410 VSS VSS.n69 0.2525
R6411 VSS VSS.n70 0.2525
R6412 VSS VSS.n71 0.2525
R6413 VSS VSS.n72 0.2525
R6414 VSS VSS.n73 0.2525
R6415 VSS VSS.n74 0.2525
R6416 VSS VSS.n65 0.2525
R6417 VSS VSS.n64 0.2525
R6418 VSS VSS.n63 0.2525
R6419 VSS VSS.n62 0.2525
R6420 VSS VSS.n61 0.2525
R6421 VSS VSS.n60 0.2525
R6422 VSS VSS.n59 0.2525
R6423 VSS VSS.n499 0.2525
R6424 VSS VSS.n500 0.2525
R6425 VSS VSS.n501 0.2525
R6426 VSS VSS.n502 0.2525
R6427 VSS VSS.n503 0.2525
R6428 VSS VSS.n504 0.2525
R6429 VSS VSS.n505 0.2525
R6430 VSS VSS.n506 0.2525
R6431 VSS.n509 VSS 0.2525
R6432 VSS.n510 VSS 0.2525
R6433 VSS.n511 VSS 0.2525
R6434 VSS.n512 VSS 0.2525
R6435 VSS.n513 VSS 0.2525
R6436 VSS.n514 VSS 0.2525
R6437 VSS.n515 VSS 0.2525
R6438 VSS.n20 VSS 0.2525
R6439 VSS.n19 VSS 0.2525
R6440 VSS.n18 VSS 0.2525
R6441 VSS VSS.n477 0.2525
R6442 VSS VSS.n478 0.2525
R6443 VSS VSS.n479 0.2525
R6444 VSS VSS.n480 0.2525
R6445 VSS VSS.n481 0.2525
R6446 VSS VSS.n482 0.2525
R6447 VSS VSS.n483 0.2525
R6448 VSS VSS.n484 0.2525
R6449 VSS.n487 VSS 0.2525
R6450 VSS.n488 VSS 0.2525
R6451 VSS.n489 VSS 0.2525
R6452 VSS.n490 VSS 0.2525
R6453 VSS.n491 VSS 0.2525
R6454 VSS.n492 VSS 0.2525
R6455 VSS.n493 VSS 0.2525
R6456 VSS.n54 VSS 0.2525
R6457 VSS.n53 VSS 0.2525
R6458 VSS.n52 VSS 0.2525
R6459 VSS.n51 VSS 0.2525
R6460 VSS.n50 VSS 0.2525
R6461 VSS.n49 VSS 0.2525
R6462 VSS.n48 VSS 0.2525
R6463 VSS.n47 VSS 0.2525
R6464 VSS VSS.n44 0.2525
R6465 VSS VSS.n43 0.2525
R6466 VSS VSS.n42 0.2525
R6467 VSS VSS.n41 0.2525
R6468 VSS VSS.n40 0.2525
R6469 VSS VSS.n39 0.2525
R6470 VSS VSS.n38 0.2525
R6471 VSS.n35 VSS 0.2525
R6472 VSS.n34 VSS 0.2525
R6473 VSS.n33 VSS 0.2525
R6474 VSS.n459 VSS 0.2525
R6475 VSS.n458 VSS 0.2525
R6476 VSS.n457 VSS 0.2525
R6477 VSS.n456 VSS 0.2525
R6478 VSS.n455 VSS 0.2525
R6479 VSS.n454 VSS 0.2525
R6480 VSS.n453 VSS 0.2525
R6481 VSS.n452 VSS 0.2525
R6482 VSS VSS.n449 0.2525
R6483 VSS VSS.n448 0.2525
R6484 VSS VSS.n447 0.2525
R6485 VSS VSS.n446 0.2525
R6486 VSS VSS.n445 0.2525
R6487 VSS VSS.n444 0.2525
R6488 VSS VSS.n443 0.2525
R6489 VSS.n440 VSS 0.2525
R6490 VSS.n439 VSS 0.2525
R6491 VSS.n438 VSS 0.2525
R6492 VSS.n437 VSS 0.2525
R6493 VSS.n436 VSS 0.2525
R6494 VSS.n435 VSS 0.2525
R6495 VSS.n434 VSS 0.2525
R6496 VSS.n433 VSS 0.2525
R6497 VSS VSS.n430 0.2525
R6498 VSS VSS.n429 0.2525
R6499 VSS VSS.n428 0.2525
R6500 VSS VSS.n427 0.2525
R6501 VSS VSS.n426 0.2525
R6502 VSS VSS.n425 0.2525
R6503 VSS VSS.n424 0.2525
R6504 VSS.n91 VSS 0.2525
R6505 VSS.n90 VSS 0.2525
R6506 VSS.n89 VSS 0.2525
R6507 VSS VSS.n366 0.2525
R6508 VSS VSS.n367 0.2525
R6509 VSS VSS.n368 0.2525
R6510 VSS VSS.n369 0.2525
R6511 VSS VSS.n370 0.2525
R6512 VSS VSS.n371 0.2525
R6513 VSS VSS.n372 0.2525
R6514 VSS VSS.n363 0.2525
R6515 VSS VSS.n362 0.2525
R6516 VSS VSS.n360 0.2525
R6517 VSS.n413 VSS 0.2525
R6518 VSS.n414 VSS 0.2525
R6519 VSS.n415 VSS 0.2525
R6520 VSS.n416 VSS 0.2525
R6521 VSS.n417 VSS 0.2525
R6522 VSS.n418 VSS 0.2525
R6523 VSS.n419 VSS 0.2525
R6524 VSS.n99 VSS 0.2525
R6525 VSS.n98 VSS 0.2525
R6526 VSS.n97 VSS 0.2525
R6527 VSS VSS.n384 0.2525
R6528 VSS VSS.n385 0.2525
R6529 VSS VSS.n386 0.2525
R6530 VSS VSS.n388 0.2525
R6531 VSS VSS.n122 0.2525
R6532 VSS VSS.n121 0.2525
R6533 VSS VSS.n120 0.2525
R6534 VSS VSS.n119 0.2525
R6535 VSS VSS.n118 0.2525
R6536 VSS VSS.n117 0.2525
R6537 VSS VSS.n116 0.2525
R6538 VSS.n113 VSS 0.2525
R6539 VSS.n112 VSS 0.2525
R6540 VSS.n111 VSS 0.2525
R6541 VSS VSS.n169 0.2525
R6542 VSS VSS.n170 0.2525
R6543 VSS VSS.n171 0.2525
R6544 VSS VSS.n172 0.2525
R6545 VSS VSS.n173 0.2525
R6546 VSS VSS.n174 0.2525
R6547 VSS VSS.n175 0.2525
R6548 VSS.n342 VSS 0.2525
R6549 VSS.n341 VSS 0.2525
R6550 VSS.n340 VSS 0.2525
R6551 VSS.n339 VSS 0.2525
R6552 VSS.n338 VSS 0.2525
R6553 VSS.n337 VSS 0.2525
R6554 VSS.n336 VSS 0.2525
R6555 VSS.n335 VSS 0.2525
R6556 VSS VSS.n332 0.2525
R6557 VSS VSS.n331 0.2525
R6558 VSS VSS.n330 0.2525
R6559 VSS.n328 VSS 0.2525
R6560 VSS VSS.n219 0.2525
R6561 VSS VSS.n220 0.2525
R6562 VSS VSS.n221 0.2525
R6563 VSS VSS.n223 0.2525
R6564 VSS VSS.n201 0.2525
R6565 VSS VSS.n307 0.2525
R6566 VSS VSS.n308 0.2525
R6567 VSS VSS.n309 0.2525
R6568 VSS VSS.n310 0.2525
R6569 VSS VSS.n311 0.2525
R6570 VSS VSS.n312 0.2525
R6571 VSS VSS.n313 0.2525
R6572 VSS.n317 VSS 0.2525
R6573 VSS.n318 VSS 0.2525
R6574 VSS.n319 VSS 0.2525
R6575 VSS.n242 VSS 0.2525
R6576 VSS.n243 VSS 0.2525
R6577 VSS.n244 VSS 0.2525
R6578 VSS VSS.n301 0.2525
R6579 VSS.n287 VSS 0.2525
R6580 VSS.n288 VSS 0.2525
R6581 VSS VSS.n279 0.2525
R6582 VSS VSS.n278 0.2525
R6583 VSS VSS.n394 0.251
R6584 VSS.n215 VSS.n214 0.25025
R6585 VSS.n398 VSS 0.2465
R6586 VSS VSS.n184 0.2465
R6587 VSS VSS.n395 0.2405
R6588 VSS.n127 VSS.n126 0.2405
R6589 VSS VSS.n250 0.2405
R6590 VSS.n204 VSS 0.23825
R6591 VSS VSS.n215 0.23675
R6592 VSS.n617 VSS 0.236
R6593 VSS.n552 VSS 0.236
R6594 VSS.n497 VSS 0.236
R6595 VSS.n494 VSS 0.236
R6596 VSS VSS.n442 0.236
R6597 VSS.n322 VSS 0.236
R6598 VSS.n190 VSS 0.2345
R6599 VSS VSS.n320 0.2285
R6600 VSS VSS.n295 0.22775
R6601 VSS.n218 VSS 0.2255
R6602 VSS VSS.n239 0.2255
R6603 VSS.n396 VSS 0.2225
R6604 VSS VSS.n189 0.2225
R6605 VSS VSS.n212 0.2225
R6606 VSS.n297 VSS 0.2225
R6607 VSS.n283 VSS 0.2225
R6608 VSS.n289 VSS 0.2225
R6609 VSS.n259 VSS 0.221
R6610 VSS.n132 VSS 0.2135
R6611 VSS.n131 VSS 0.2135
R6612 VSS VSS.n162 0.209
R6613 VSS.n399 VSS 0.2045
R6614 VSS VSS.n188 0.2045
R6615 VSS.n179 VSS 0.2
R6616 VSS.n265 VSS 0.2
R6617 VSS.n9 VSS 0.1985
R6618 VSS.n520 VSS 0.1985
R6619 VSS.n17 VSS 0.1985
R6620 VSS.n32 VSS 0.1985
R6621 VSS.n88 VSS 0.1985
R6622 VSS VSS.n373 0.1985
R6623 VSS.n358 VSS 0.1985
R6624 VSS.n96 VSS 0.1985
R6625 VSS VSS.n387 0.1985
R6626 VSS VSS.n389 0.1985
R6627 VSS.n110 VSS 0.1985
R6628 VSS VSS.n176 0.1985
R6629 VSS.n327 VSS 0.1985
R6630 VSS VSS.n222 0.1985
R6631 VSS VSS.n224 0.1985
R6632 VSS VSS.n314 0.1985
R6633 VSS VSS.n302 0.1985
R6634 VSS.n258 VSS 0.1985
R6635 VSS.n257 VSS 0.1985
R6636 VSS VSS.n277 0.197
R6637 VSS VSS.n276 0.197
R6638 VSS VSS.n262 0.197
R6639 VSS VSS.n261 0.197
R6640 VSS VSS.n160 0.1955
R6641 VSS VSS.n251 0.1955
R6642 VSS VSS.n252 0.1955
R6643 VSS VSS.n364 0.1925
R6644 VSS VSS.n578 0.1865
R6645 VSS.n571 VSS 0.1865
R6646 VSS.n516 VSS 0.1865
R6647 VSS VSS.n37 0.1865
R6648 VSS VSS.n423 0.1865
R6649 VSS.n420 VSS 0.1865
R6650 VSS VSS.n115 0.1865
R6651 VSS.n181 VSS 0.1865
R6652 VSS VSS.n187 0.1865
R6653 VSS.n253 VSS 0.1865
R6654 VSS.n393 VSS.n392 0.185
R6655 VSS.n575 VSS 0.1805
R6656 VSS VSS.n238 0.1805
R6657 VSS VSS.n196 0.1745
R6658 VSS VSS.n321 0.1745
R6659 VSS.n8 VSS 0.173628
R6660 VSS.n628 VSS 0.173628
R6661 VSS.n16 VSS 0.173628
R6662 VSS.n471 VSS 0.173628
R6663 VSS.n87 VSS 0.173628
R6664 VSS.n462 VSS 0.173628
R6665 VSS.n95 VSS 0.173628
R6666 VSS.n378 VSS 0.173628
R6667 VSS.n109 VSS 0.173628
R6668 VSS.n349 VSS 0.173628
R6669 VSS.n159 VSS 0.173628
R6670 VSS.n354 VSS 0.173628
R6671 VSS.n200 VSS 0.173628
R6672 VSS.n345 VSS 0.173628
R6673 VSS.n228 VSS 0.173628
R6674 VSS.n145 VSS 0.173628
R6675 VSS.n151 VSS 0.173628
R6676 VSS.n294 VSS 0.173628
R6677 VSS.n31 VSS 0.173628
R6678 VSS.n466 VSS 0.173628
R6679 VSS.n519 VSS 0.173628
R6680 VSS.n532 VSS 0.173628
R6681 VSS.n404 VSS 0.1685
R6682 VSS VSS.n404 0.1685
R6683 VSS.n405 VSS 0.1685
R6684 VSS VSS.n405 0.1685
R6685 VSS.n406 VSS 0.1685
R6686 VSS VSS.n406 0.1685
R6687 VSS.n407 VSS 0.1685
R6688 VSS VSS.n407 0.1685
R6689 VSS.n408 VSS 0.1685
R6690 VSS VSS.n408 0.1685
R6691 VSS.n409 VSS 0.1685
R6692 VSS VSS.n409 0.1685
R6693 VSS VSS.n410 0.1685
R6694 VSS VSS.n231 0.1685
R6695 VSS.n231 VSS 0.1685
R6696 VSS.n230 VSS 0.1685
R6697 VSS VSS.n229 0.1685
R6698 VSS.n229 VSS 0.1685
R6699 VSS.n298 VSS 0.1685
R6700 VSS VSS.n298 0.1685
R6701 VSS.n299 VSS 0.1685
R6702 VSS.n284 VSS 0.1685
R6703 VSS VSS.n266 0.1685
R6704 VSS.n267 VSS 0.1685
R6705 VSS VSS.n267 0.1685
R6706 VSS.n268 VSS 0.1685
R6707 VSS VSS.n268 0.1685
R6708 VSS.n269 VSS 0.1685
R6709 VSS VSS.n269 0.1685
R6710 VSS VSS.n270 0.1685
R6711 VSS.n271 VSS 0.1685
R6712 VSS VSS.n271 0.1685
R6713 VSS.n156 VSS 0.1685
R6714 VSS VSS.n155 0.1685
R6715 VSS.n155 VSS 0.1685
R6716 VSS VSS.n154 0.1685
R6717 VSS.n154 VSS 0.1685
R6718 VSS VSS.n153 0.1685
R6719 VSS VSS.n152 0.1685
R6720 VSS.n260 VSS 0.167
R6721 VSS.n396 VSS 0.165941
R6722 VSS.n390 VSS 0.165941
R6723 VSS.n182 VSS 0.165941
R6724 VSS.n212 VSS 0.165941
R6725 VSS.n264 VSS 0.165941
R6726 VSS VSS.n161 0.164
R6727 VSS.n238 VSS 0.1565
R6728 VSS.n394 VSS.n393 0.152
R6729 VSS.n326 VSS.n325 0.152
R6730 VSS.n365 VSS 0.1445
R6731 VSS.n390 VSS 0.1445
R6732 VSS VSS.n300 0.14375
R6733 VSS.n252 VSS 0.1415
R6734 VSS.n277 VSS 0.14
R6735 VSS.n300 VSS 0.1385
R6736 VSS VSS.n178 0.137
R6737 VSS VSS.n265 0.137
R6738 VSS VSS.n390 0.1325
R6739 VSS.n162 VSS 0.128
R6740 VSS.n197 VSS 0.1265
R6741 VSS.n587 VSS.n5 0.123588
R6742 VSS.n608 VSS.n599 0.123588
R6743 VSS.n562 VSS.n518 0.123588
R6744 VSS.n507 VSS.n15 0.123588
R6745 VSS.n76 VSS.n75 0.123588
R6746 VSS.n46 VSS.n28 0.123588
R6747 VSS.n432 VSS.n84 0.123588
R6748 VSS.n451 VSS.n81 0.123588
R6749 VSS.n374 VSS 0.123588
R6750 VSS.n411 VSS.n94 0.123588
R6751 VSS.n124 VSS.n106 0.123588
R6752 VSS.n394 VSS 0.123588
R6753 VSS.n392 VSS 0.123588
R6754 VSS.n391 VSS.n105 0.123588
R6755 VSS.n194 VSS.n158 0.123588
R6756 VSS.n192 VSS 0.123588
R6757 VSS.n191 VSS 0.123588
R6758 VSS.n179 VSS 0.123588
R6759 VSS.n178 VSS 0.123588
R6760 VSS.n177 VSS.n168 0.123588
R6761 VSS.n203 VSS 0.123588
R6762 VSS.n204 VSS 0.123588
R6763 VSS.n216 VSS.n199 0.123588
R6764 VSS.n215 VSS 0.123588
R6765 VSS.n213 VSS 0.123588
R6766 VSS.n334 VSS.n140 0.123588
R6767 VSS.n245 VSS.n227 0.123588
R6768 VSS.n315 VSS.n142 0.123588
R6769 VSS.n259 VSS 0.123588
R6770 VSS.n260 VSS 0.123588
R6771 VSS.n261 VSS 0.123588
R6772 VSS.n262 VSS 0.123588
R6773 VSS.n263 VSS.n148 0.123588
R6774 VSS.n265 VSS 0.123588
R6775 VSS.n275 VSS 0.123588
R6776 VSS.n276 VSS 0.123588
R6777 VSS.n277 VSS 0.123588
R6778 VSS.n282 VSS.n147 0.123588
R6779 VSS.n485 VSS.n27 0.123588
R6780 VSS.n543 VSS.n528 0.123588
R6781 VSS VSS.n132 0.1235
R6782 VSS VSS.n130 0.1235
R6783 VSS.n125 VSS 0.1205
R6784 VSS VSS.n259 0.116
R6785 VSS VSS.n195 0.1145
R6786 VSS VSS.n211 0.1145
R6787 VSS VSS.n296 0.1145
R6788 VSS VSS.n299 0.1145
R6789 VSS VSS.n284 0.1145
R6790 VSS VSS.n290 0.1145
R6791 VSS.n153 VSS 0.1145
R6792 VSS.n152 VSS 0.1145
R6793 VSS VSS.n203 0.113
R6794 VSS.n130 VSS 0.112022
R6795 VSS.n131 VSS 0.112022
R6796 VSS.n132 VSS 0.112022
R6797 VSS.n160 VSS 0.112022
R6798 VSS.n161 VSS 0.112022
R6799 VSS.n162 VSS 0.112022
R6800 VSS.n185 VSS 0.112022
R6801 VSS.n184 VSS 0.112022
R6802 VSS.n183 VSS 0.112022
R6803 VSS.n240 VSS 0.112022
R6804 VSS.n239 VSS 0.112022
R6805 VSS.n238 VSS 0.112022
R6806 VSS.n5 VSS 0.111676
R6807 VSS.n599 VSS 0.111676
R6808 VSS.n518 VSS 0.111676
R6809 VSS.n15 VSS 0.111676
R6810 VSS.n76 VSS 0.111676
R6811 VSS.n28 VSS 0.111676
R6812 VSS.n84 VSS 0.111676
R6813 VSS.n81 VSS 0.111676
R6814 VSS.n374 VSS 0.111676
R6815 VSS.n94 VSS 0.111676
R6816 VSS.n106 VSS 0.111676
R6817 VSS.n105 VSS 0.111676
R6818 VSS.n158 VSS 0.111676
R6819 VSS.n168 VSS 0.111676
R6820 VSS.n199 VSS 0.111676
R6821 VSS.n140 VSS 0.111676
R6822 VSS.n227 VSS 0.111676
R6823 VSS.n142 VSS 0.111676
R6824 VSS.n148 VSS 0.111676
R6825 VSS.n147 VSS 0.111676
R6826 VSS.n27 VSS 0.111676
R6827 VSS.n528 VSS 0.111676
R6828 VSS VSS.n217 0.1115
R6829 VSS VSS.n218 0.1115
R6830 VSS.n239 VSS 0.1115
R6831 VSS.n240 VSS 0.1115
R6832 VSS.n196 VSS 0.1085
R6833 VSS.n575 VSS 0.1025
R6834 VSS VSS.n255 0.1025
R6835 VSS.n214 VSS.n213 0.101
R6836 VSS VSS.n204 0.09875
R6837 VSS.n128 VSS.n127 0.0965
R6838 VSS.n187 VSS 0.0965
R6839 VSS.n251 VSS 0.0965
R6840 VSS.n253 VSS 0.0965
R6841 VSS.n130 VSS 0.0875
R6842 VSS.n183 VSS 0.0875
R6843 VSS.n188 VSS 0.0875
R6844 VSS.n161 VSS 0.0875
R6845 VSS.n160 VSS 0.0875
R6846 VSS VSS.n240 0.0875
R6847 VSS.n178 VSS 0.086
R6848 VSS.n213 VSS 0.086
R6849 VSS.n203 VSS 0.086
R6850 VSS.n276 VSS 0.086
R6851 VSS.n262 VSS 0.086
R6852 VSS.n261 VSS 0.086
R6853 VSS.n600 VSS 0.0845
R6854 VSS.n601 VSS 0.0845
R6855 VSS.n602 VSS 0.0845
R6856 VSS.n603 VSS 0.0845
R6857 VSS.n604 VSS 0.0845
R6858 VSS.n605 VSS 0.0845
R6859 VSS.n606 VSS 0.0845
R6860 VSS.n608 VSS 0.0845
R6861 VSS VSS.n608 0.0845
R6862 VSS VSS.n609 0.0845
R6863 VSS VSS.n610 0.0845
R6864 VSS VSS.n611 0.0845
R6865 VSS VSS.n612 0.0845
R6866 VSS VSS.n613 0.0845
R6867 VSS VSS.n614 0.0845
R6868 VSS VSS.n615 0.0845
R6869 VSS VSS.n595 0.0845
R6870 VSS VSS.n594 0.0845
R6871 VSS VSS.n593 0.0845
R6872 VSS VSS.n592 0.0845
R6873 VSS VSS.n591 0.0845
R6874 VSS VSS.n590 0.0845
R6875 VSS VSS.n589 0.0845
R6876 VSS VSS.n587 0.0845
R6877 VSS.n587 VSS 0.0845
R6878 VSS.n586 VSS 0.0845
R6879 VSS.n585 VSS 0.0845
R6880 VSS.n584 VSS 0.0845
R6881 VSS.n583 VSS 0.0845
R6882 VSS.n582 VSS 0.0845
R6883 VSS.n581 VSS 0.0845
R6884 VSS.n580 VSS 0.0845
R6885 VSS VSS.n12 0.0845
R6886 VSS VSS.n11 0.0845
R6887 VSS VSS.n10 0.0845
R6888 VSS.n535 VSS 0.0845
R6889 VSS.n536 VSS 0.0845
R6890 VSS.n537 VSS 0.0845
R6891 VSS.n538 VSS 0.0845
R6892 VSS.n539 VSS 0.0845
R6893 VSS.n540 VSS 0.0845
R6894 VSS.n541 VSS 0.0845
R6895 VSS.n543 VSS 0.0845
R6896 VSS VSS.n543 0.0845
R6897 VSS VSS.n544 0.0845
R6898 VSS VSS.n545 0.0845
R6899 VSS VSS.n546 0.0845
R6900 VSS VSS.n547 0.0845
R6901 VSS VSS.n548 0.0845
R6902 VSS VSS.n549 0.0845
R6903 VSS VSS.n550 0.0845
R6904 VSS.n554 VSS 0.0845
R6905 VSS.n555 VSS 0.0845
R6906 VSS.n556 VSS 0.0845
R6907 VSS.n557 VSS 0.0845
R6908 VSS.n558 VSS 0.0845
R6909 VSS.n559 VSS 0.0845
R6910 VSS.n560 VSS 0.0845
R6911 VSS.n562 VSS 0.0845
R6912 VSS VSS.n562 0.0845
R6913 VSS VSS.n563 0.0845
R6914 VSS VSS.n564 0.0845
R6915 VSS VSS.n565 0.0845
R6916 VSS VSS.n566 0.0845
R6917 VSS VSS.n567 0.0845
R6918 VSS VSS.n568 0.0845
R6919 VSS VSS.n569 0.0845
R6920 VSS VSS.n523 0.0845
R6921 VSS VSS.n522 0.0845
R6922 VSS VSS.n521 0.0845
R6923 VSS.n67 VSS 0.0845
R6924 VSS.n68 VSS 0.0845
R6925 VSS.n69 VSS 0.0845
R6926 VSS.n70 VSS 0.0845
R6927 VSS.n71 VSS 0.0845
R6928 VSS.n72 VSS 0.0845
R6929 VSS.n73 VSS 0.0845
R6930 VSS.n75 VSS 0.0845
R6931 VSS.n75 VSS 0.0845
R6932 VSS.n66 VSS 0.0845
R6933 VSS.n65 VSS 0.0845
R6934 VSS.n64 VSS 0.0845
R6935 VSS.n63 VSS 0.0845
R6936 VSS.n62 VSS 0.0845
R6937 VSS.n61 VSS 0.0845
R6938 VSS.n60 VSS 0.0845
R6939 VSS.n499 VSS 0.0845
R6940 VSS.n500 VSS 0.0845
R6941 VSS.n501 VSS 0.0845
R6942 VSS.n502 VSS 0.0845
R6943 VSS.n503 VSS 0.0845
R6944 VSS.n504 VSS 0.0845
R6945 VSS.n505 VSS 0.0845
R6946 VSS.n507 VSS 0.0845
R6947 VSS VSS.n507 0.0845
R6948 VSS VSS.n508 0.0845
R6949 VSS VSS.n509 0.0845
R6950 VSS VSS.n510 0.0845
R6951 VSS VSS.n511 0.0845
R6952 VSS VSS.n512 0.0845
R6953 VSS VSS.n513 0.0845
R6954 VSS VSS.n514 0.0845
R6955 VSS VSS.n20 0.0845
R6956 VSS VSS.n19 0.0845
R6957 VSS VSS.n18 0.0845
R6958 VSS.n477 VSS 0.0845
R6959 VSS.n478 VSS 0.0845
R6960 VSS.n479 VSS 0.0845
R6961 VSS.n480 VSS 0.0845
R6962 VSS.n481 VSS 0.0845
R6963 VSS.n482 VSS 0.0845
R6964 VSS.n483 VSS 0.0845
R6965 VSS.n485 VSS 0.0845
R6966 VSS VSS.n485 0.0845
R6967 VSS VSS.n486 0.0845
R6968 VSS VSS.n487 0.0845
R6969 VSS VSS.n488 0.0845
R6970 VSS VSS.n489 0.0845
R6971 VSS VSS.n490 0.0845
R6972 VSS VSS.n491 0.0845
R6973 VSS VSS.n492 0.0845
R6974 VSS VSS.n54 0.0845
R6975 VSS VSS.n53 0.0845
R6976 VSS VSS.n52 0.0845
R6977 VSS VSS.n51 0.0845
R6978 VSS VSS.n50 0.0845
R6979 VSS VSS.n49 0.0845
R6980 VSS VSS.n48 0.0845
R6981 VSS VSS.n46 0.0845
R6982 VSS.n46 VSS 0.0845
R6983 VSS.n45 VSS 0.0845
R6984 VSS.n44 VSS 0.0845
R6985 VSS.n43 VSS 0.0845
R6986 VSS.n42 VSS 0.0845
R6987 VSS.n41 VSS 0.0845
R6988 VSS.n40 VSS 0.0845
R6989 VSS.n39 VSS 0.0845
R6990 VSS VSS.n35 0.0845
R6991 VSS VSS.n34 0.0845
R6992 VSS VSS.n33 0.0845
R6993 VSS VSS.n459 0.0845
R6994 VSS VSS.n458 0.0845
R6995 VSS VSS.n457 0.0845
R6996 VSS VSS.n456 0.0845
R6997 VSS VSS.n455 0.0845
R6998 VSS VSS.n454 0.0845
R6999 VSS VSS.n453 0.0845
R7000 VSS VSS.n451 0.0845
R7001 VSS.n451 VSS 0.0845
R7002 VSS.n450 VSS 0.0845
R7003 VSS.n449 VSS 0.0845
R7004 VSS.n448 VSS 0.0845
R7005 VSS.n447 VSS 0.0845
R7006 VSS.n446 VSS 0.0845
R7007 VSS.n445 VSS 0.0845
R7008 VSS.n444 VSS 0.0845
R7009 VSS VSS.n440 0.0845
R7010 VSS VSS.n439 0.0845
R7011 VSS VSS.n438 0.0845
R7012 VSS VSS.n437 0.0845
R7013 VSS VSS.n436 0.0845
R7014 VSS VSS.n435 0.0845
R7015 VSS VSS.n434 0.0845
R7016 VSS VSS.n432 0.0845
R7017 VSS.n432 VSS 0.0845
R7018 VSS.n431 VSS 0.0845
R7019 VSS.n430 VSS 0.0845
R7020 VSS.n429 VSS 0.0845
R7021 VSS.n428 VSS 0.0845
R7022 VSS.n427 VSS 0.0845
R7023 VSS.n426 VSS 0.0845
R7024 VSS.n425 VSS 0.0845
R7025 VSS VSS.n91 0.0845
R7026 VSS VSS.n90 0.0845
R7027 VSS VSS.n89 0.0845
R7028 VSS.n366 VSS 0.0845
R7029 VSS.n367 VSS 0.0845
R7030 VSS.n368 VSS 0.0845
R7031 VSS.n369 VSS 0.0845
R7032 VSS.n370 VSS 0.0845
R7033 VSS.n371 VSS 0.0845
R7034 VSS.n372 VSS 0.0845
R7035 VSS.n363 VSS 0.0845
R7036 VSS.n362 VSS 0.0845
R7037 VSS.n361 VSS 0.0845
R7038 VSS.n411 VSS 0.0845
R7039 VSS VSS.n411 0.0845
R7040 VSS VSS.n412 0.0845
R7041 VSS VSS.n413 0.0845
R7042 VSS VSS.n414 0.0845
R7043 VSS VSS.n415 0.0845
R7044 VSS VSS.n416 0.0845
R7045 VSS VSS.n417 0.0845
R7046 VSS VSS.n418 0.0845
R7047 VSS VSS.n99 0.0845
R7048 VSS VSS.n98 0.0845
R7049 VSS VSS.n97 0.0845
R7050 VSS.n384 VSS 0.0845
R7051 VSS.n385 VSS 0.0845
R7052 VSS.n386 VSS 0.0845
R7053 VSS.n388 VSS 0.0845
R7054 VSS.n391 VSS 0.0845
R7055 VSS VSS.n391 0.0845
R7056 VSS.n124 VSS 0.0845
R7057 VSS.n122 VSS 0.0845
R7058 VSS.n121 VSS 0.0845
R7059 VSS.n120 VSS 0.0845
R7060 VSS.n119 VSS 0.0845
R7061 VSS.n118 VSS 0.0845
R7062 VSS.n117 VSS 0.0845
R7063 VSS.n116 VSS 0.0845
R7064 VSS VSS.n113 0.0845
R7065 VSS VSS.n112 0.0845
R7066 VSS VSS.n111 0.0845
R7067 VSS.n169 VSS 0.0845
R7068 VSS.n170 VSS 0.0845
R7069 VSS.n171 VSS 0.0845
R7070 VSS.n172 VSS 0.0845
R7071 VSS.n173 VSS 0.0845
R7072 VSS.n174 VSS 0.0845
R7073 VSS.n175 VSS 0.0845
R7074 VSS.n177 VSS 0.0845
R7075 VSS VSS.n177 0.0845
R7076 VSS.n194 VSS 0.0845
R7077 VSS VSS.n194 0.0845
R7078 VSS VSS.n342 0.0845
R7079 VSS VSS.n341 0.0845
R7080 VSS VSS.n340 0.0845
R7081 VSS VSS.n339 0.0845
R7082 VSS VSS.n338 0.0845
R7083 VSS VSS.n337 0.0845
R7084 VSS VSS.n336 0.0845
R7085 VSS VSS.n334 0.0845
R7086 VSS.n334 VSS 0.0845
R7087 VSS.n333 VSS 0.0845
R7088 VSS.n332 VSS 0.0845
R7089 VSS.n331 VSS 0.0845
R7090 VSS.n330 VSS 0.0845
R7091 VSS VSS.n327 0.0845
R7092 VSS VSS.n326 0.0845
R7093 VSS VSS.n210 0.0845
R7094 VSS VSS.n216 0.0845
R7095 VSS.n219 VSS 0.0845
R7096 VSS.n220 VSS 0.0845
R7097 VSS.n221 VSS 0.0845
R7098 VSS.n222 VSS 0.0845
R7099 VSS.n223 VSS 0.0845
R7100 VSS.n224 VSS 0.0845
R7101 VSS.n202 VSS 0.0845
R7102 VSS.n201 VSS 0.0845
R7103 VSS.n307 VSS 0.0845
R7104 VSS.n308 VSS 0.0845
R7105 VSS.n309 VSS 0.0845
R7106 VSS.n310 VSS 0.0845
R7107 VSS.n311 VSS 0.0845
R7108 VSS.n312 VSS 0.0845
R7109 VSS.n313 VSS 0.0845
R7110 VSS.n315 VSS 0.0845
R7111 VSS VSS.n315 0.0845
R7112 VSS VSS.n316 0.0845
R7113 VSS VSS.n317 0.0845
R7114 VSS VSS.n318 0.0845
R7115 VSS VSS.n241 0.0845
R7116 VSS VSS.n243 0.0845
R7117 VSS.n245 VSS 0.0845
R7118 VSS.n301 VSS 0.0845
R7119 VSS.n302 VSS 0.0845
R7120 VSS VSS.n287 0.0845
R7121 VSS VSS.n282 0.0845
R7122 VSS.n282 VSS 0.0845
R7123 VSS.n279 VSS 0.0845
R7124 VSS VSS.n263 0.0845
R7125 VSS.n263 VSS 0.0845
R7126 VSS VSS.n257 0.0845
R7127 VSS.n275 VSS 0.083
R7128 VSS.n623 VSS 0.0815
R7129 VSS.n626 VSS 0.0815
R7130 VSS VSS.n534 0.0815
R7131 VSS.n473 VSS 0.0815
R7132 VSS VSS.n476 0.0815
R7133 VSS.n460 VSS 0.0815
R7134 VSS.n380 VSS 0.0815
R7135 VSS VSS.n383 0.0815
R7136 VSS.n356 VSS 0.0815
R7137 VSS.n343 VSS 0.0815
R7138 VSS VSS.n306 0.0815
R7139 VSS.n304 VSS 0.0815
R7140 VSS VSS.n131 0.0785
R7141 VSS VSS.n245 0.0785
R7142 VSS VSS.n179 0.077
R7143 VSS.n133 VSS 0.0759412
R7144 VSS.n398 VSS 0.0759412
R7145 VSS.n397 VSS 0.0759412
R7146 VSS.n157 VSS 0.0759412
R7147 VSS.n196 VSS 0.0759412
R7148 VSS.n195 VSS 0.0759412
R7149 VSS.n189 VSS 0.0759412
R7150 VSS.n188 VSS 0.0759412
R7151 VSS.n187 VSS 0.0759412
R7152 VSS.n237 VSS 0.0759412
R7153 VSS.n321 VSS 0.0759412
R7154 VSS.n320 VSS 0.0759412
R7155 VSS.n189 VSS 0.0725
R7156 VSS.n225 VSS 0.0725
R7157 VSS.n133 VSS 0.0665
R7158 VSS VSS.n157 0.0665
R7159 VSS VSS.n237 0.0665
R7160 VSS.n255 VSS.n156 0.0665
R7161 VSS.n628 VSS 0.0625365
R7162 VSS VSS.n471 0.0625365
R7163 VSS.n462 VSS 0.0625365
R7164 VSS VSS.n87 0.0625365
R7165 VSS VSS.n378 0.0625365
R7166 VSS VSS.n95 0.0625365
R7167 VSS.n349 VSS 0.0625365
R7168 VSS VSS.n109 0.0625365
R7169 VSS VSS.n354 0.0625365
R7170 VSS VSS.n159 0.0625365
R7171 VSS.n345 VSS 0.0625365
R7172 VSS VSS.n200 0.0625365
R7173 VSS VSS.n145 0.0625365
R7174 VSS VSS.n228 0.0625365
R7175 VSS VSS.n294 0.0625365
R7176 VSS VSS.n151 0.0625365
R7177 VSS VSS.n31 0.0625365
R7178 VSS.n466 VSS 0.0625365
R7179 VSS VSS.n16 0.0625365
R7180 VSS VSS.n519 0.0625365
R7181 VSS VSS.n532 0.0625365
R7182 VSS VSS.n8 0.0625365
R7183 VSS VSS.n297 0.05975
R7184 VSS VSS.n283 0.05975
R7185 VSS VSS.n289 0.05975
R7186 VSS VSS.n260 0.056
R7187 VSS VSS.n627 0.0545
R7188 VSS.n607 VSS 0.0545
R7189 VSS.n609 VSS 0.0545
R7190 VSS VSS.n588 0.0545
R7191 VSS VSS.n586 0.0545
R7192 VSS VSS.n13 0.0545
R7193 VSS VSS.n9 0.0545
R7194 VSS.n533 VSS 0.0545
R7195 VSS.n542 VSS 0.0545
R7196 VSS.n544 VSS 0.0545
R7197 VSS.n561 VSS 0.0545
R7198 VSS.n563 VSS 0.0545
R7199 VSS.n524 VSS 0.0545
R7200 VSS VSS.n520 0.0545
R7201 VSS.n472 VSS 0.0545
R7202 VSS.n74 VSS 0.0545
R7203 VSS VSS.n66 0.0545
R7204 VSS.n506 VSS 0.0545
R7205 VSS.n508 VSS 0.0545
R7206 VSS.n21 VSS 0.0545
R7207 VSS VSS.n17 0.0545
R7208 VSS VSS.n465 0.0545
R7209 VSS.n484 VSS 0.0545
R7210 VSS.n486 VSS 0.0545
R7211 VSS VSS.n47 0.0545
R7212 VSS VSS.n45 0.0545
R7213 VSS VSS.n36 0.0545
R7214 VSS VSS.n32 0.0545
R7215 VSS VSS.n461 0.0545
R7216 VSS VSS.n452 0.0545
R7217 VSS VSS.n450 0.0545
R7218 VSS VSS.n433 0.0545
R7219 VSS VSS.n431 0.0545
R7220 VSS VSS.n92 0.0545
R7221 VSS VSS.n88 0.0545
R7222 VSS.n379 VSS 0.0545
R7223 VSS.n373 VSS 0.0545
R7224 VSS VSS.n365 0.0545
R7225 VSS VSS.n361 0.0545
R7226 VSS.n403 VSS 0.0545
R7227 VSS.n410 VSS 0.0545
R7228 VSS.n412 VSS 0.0545
R7229 VSS.n100 VSS 0.0545
R7230 VSS VSS.n96 0.0545
R7231 VSS VSS.n348 0.0545
R7232 VSS.n387 VSS 0.0545
R7233 VSS.n389 VSS 0.0545
R7234 VSS.n395 VSS 0.0545
R7235 VSS.n397 VSS 0.0545
R7236 VSS VSS.n129 0.0545
R7237 VSS VSS.n128 0.0545
R7238 VSS VSS.n125 0.0545
R7239 VSS VSS.n124 0.0545
R7240 VSS VSS.n123 0.0545
R7241 VSS VSS.n114 0.0545
R7242 VSS VSS.n110 0.0545
R7243 VSS.n355 VSS 0.0545
R7244 VSS.n176 VSS 0.0545
R7245 VSS.n180 VSS 0.0545
R7246 VSS.n193 VSS 0.0545
R7247 VSS.n195 VSS 0.0545
R7248 VSS VSS.n344 0.0545
R7249 VSS VSS.n335 0.0545
R7250 VSS VSS.n333 0.0545
R7251 VSS VSS.n328 0.0545
R7252 VSS.n209 VSS 0.0545
R7253 VSS.n210 VSS 0.0545
R7254 VSS.n211 VSS 0.0545
R7255 VSS.n217 VSS 0.0545
R7256 VSS VSS.n202 0.0545
R7257 VSS.n146 VSS 0.0545
R7258 VSS.n314 VSS 0.0545
R7259 VSS.n316 VSS 0.0545
R7260 VSS.n320 VSS 0.0545
R7261 VSS.n241 VSS 0.0545
R7262 VSS.n246 VSS 0.0545
R7263 VSS VSS.n248 0.0545
R7264 VSS.n249 VSS 0.0545
R7265 VSS.n232 VSS 0.0545
R7266 VSS VSS.n230 0.0545
R7267 VSS.n295 VSS 0.0545
R7268 VSS.n296 VSS 0.0545
R7269 VSS.n303 VSS 0.0545
R7270 VSS.n285 VSS 0.0545
R7271 VSS.n290 VSS 0.0545
R7272 VSS VSS.n281 0.0545
R7273 VSS.n266 VSS 0.0545
R7274 VSS.n270 VSS 0.0545
R7275 VSS.n264 VSS 0.0545
R7276 VSS VSS.n258 0.0545
R7277 VSS VSS.n256 0.0545
R7278 VSS.n393 VSS 0.0541842
R7279 VSS.n127 VSS 0.0541842
R7280 VSS.n181 VSS 0.0541842
R7281 VSS.n190 VSS 0.0541842
R7282 VSS.n214 VSS 0.0541842
R7283 VSS.n247 VSS 0.0541842
R7284 VSS VSS.n359 0.053
R7285 VSS VSS.n358 0.053
R7286 VSS.n321 VSS 0.0485
R7287 VSS VSS.n402 0.047
R7288 VSS.n399 VSS 0.047
R7289 VSS VSS.n186 0.047
R7290 VSS.n325 VSS 0.047
R7291 VSS.n322 VSS 0.047
R7292 VSS.n184 VSS 0.0455
R7293 VSS.n185 VSS 0.0455
R7294 VSS.n216 VSS 0.0425
R7295 VSS.n186 VSS 0.041
R7296 VSS VSS.n620 0.038
R7297 VSS.n402 VSS 0.038
R7298 VSS VSS.n141 0.038
R7299 VSS.n182 VSS.n181 0.0365
R7300 VSS VSS.n193 0.0365
R7301 VSS.n627 VSS 0.0305
R7302 VSS VSS.n616 0.0305
R7303 VSS VSS.n4 0.0305
R7304 VSS.n579 VSS 0.0305
R7305 VSS.n13 VSS 0.0305
R7306 VSS VSS.n533 0.0305
R7307 VSS VSS.n551 0.0305
R7308 VSS VSS.n553 0.0305
R7309 VSS VSS.n570 0.0305
R7310 VSS VSS.n524 0.0305
R7311 VSS VSS.n472 0.0305
R7312 VSS.n59 VSS 0.0305
R7313 VSS VSS.n498 0.0305
R7314 VSS VSS.n515 0.0305
R7315 VSS VSS.n21 0.0305
R7316 VSS.n465 VSS 0.0305
R7317 VSS VSS.n493 0.0305
R7318 VSS VSS.n26 0.0305
R7319 VSS.n38 VSS 0.0305
R7320 VSS.n36 VSS 0.0305
R7321 VSS.n461 VSS 0.0305
R7322 VSS.n443 VSS 0.0305
R7323 VSS.n441 VSS 0.0305
R7324 VSS.n424 VSS 0.0305
R7325 VSS.n92 VSS 0.0305
R7326 VSS VSS.n379 0.0305
R7327 VSS.n364 VSS 0.0305
R7328 VSS.n360 VSS 0.0305
R7329 VSS VSS.n403 0.0305
R7330 VSS VSS.n419 0.0305
R7331 VSS VSS.n100 0.0305
R7332 VSS.n348 VSS 0.0305
R7333 VSS VSS.n397 0.0305
R7334 VSS.n123 VSS 0.0305
R7335 VSS.n114 VSS 0.0305
R7336 VSS VSS.n355 0.0305
R7337 VSS.n197 VSS.n157 0.0305
R7338 VSS.n344 VSS 0.0305
R7339 VSS VSS.n209 0.0305
R7340 VSS VSS.n146 0.0305
R7341 VSS VSS.n319 0.0305
R7342 VSS VSS.n242 0.0305
R7343 VSS VSS.n244 0.0305
R7344 VSS VSS.n232 0.0305
R7345 VSS VSS.n303 0.0305
R7346 VSS VSS.n285 0.0305
R7347 VSS VSS.n286 0.0305
R7348 VSS VSS.n288 0.0305
R7349 VSS.n281 VSS 0.0305
R7350 VSS.n280 VSS 0.0305
R7351 VSS.n278 VSS 0.0305
R7352 VSS VSS.n264 0.0305
R7353 VSS.n256 VSS 0.0305
R7354 VSS VSS.n396 0.0275
R7355 VSS.n286 VSS 0.02525
R7356 VSS VSS.n280 0.02525
R7357 VSS.n329 VSS 0.0245
R7358 VSS VSS.n133 0.0185
R7359 VSS.n237 VSS 0.0185
R7360 VSS.n624 VSS 0.017375
R7361 VSS.n619 VSS 0.017375
R7362 VSS.n576 VSS 0.017375
R7363 VSS.n620 VSS 0.017
R7364 VSS.n617 VSS.n4 0.017
R7365 VSS.n553 VSS.n552 0.017
R7366 VSS.n498 VSS.n497 0.017
R7367 VSS.n494 VSS.n26 0.017
R7368 VSS.n442 VSS.n441 0.017
R7369 VSS.n191 VSS.n190 0.017
R7370 VSS VSS.n141 0.017
R7371 VSS.n578 VSS 0.0125
R7372 VSS.n571 VSS 0.0125
R7373 VSS.n516 VSS 0.0125
R7374 VSS.n37 VSS 0.0125
R7375 VSS.n423 VSS 0.0125
R7376 VSS.n420 VSS 0.0125
R7377 VSS.n115 VSS 0.0125
R7378 VSS.n225 VSS 0.0125
R7379 VSS.n248 VSS.n247 0.0125
R7380 VSS VSS.n398 0.008
R7381 VSS.n623 VSS 0.0035
R7382 VSS VSS.n626 0.0035
R7383 VSS.n534 VSS 0.0035
R7384 VSS.n473 VSS 0.0035
R7385 VSS.n476 VSS 0.0035
R7386 VSS VSS.n460 0.0035
R7387 VSS.n380 VSS 0.0035
R7388 VSS.n383 VSS 0.0035
R7389 VSS.n356 VSS 0.0035
R7390 VSS VSS.n343 0.0035
R7391 VSS.n306 VSS 0.0035
R7392 VSS.n304 VSS 0.0035
R7393 VSS VSS.n275 0.002
C0 a_18492_3160# a_18604_2727# 0.02634f
C1 a_4852_7528# a_4964_6340# 0.02666f
C2 a_21404_14136# ana_div_chain\[0\]_dff_notouch_.Q 0.02785f
C3 a_19500_8999# VDD 0.38302f
C4 a_10116_17316# VDD 0.23515f
C5 a_17956_3204# VDD 0.23149f
C6 a_14036_7528# VDD 0.22827f
C7 a_21516_8999# a_21428_9096# 0.30831f
C8 dac_div_chain\[4\]_inv_notouch_.I VDD 0.49266f
C9 a_6732_5863# a_7092_5960# 0.08707f
C10 a_5860_15748# VDD 0.22854f
C11 a_8100_4772# VDD 0.23473f
C12 a_10652_7864# a_10764_7431# 0.02634f
C13 input1.Z ana_div_chain\[1\]_dff_notouch_.CLK 0.12995f
C14 a_21540_7908# a_21180_7864# 0.0869f
C15 a_12892_18407# VDD 0.3407f
C16 a_21428_10664# a_21540_9476# 0.02666f
C17 a_12038_17744# dvo[4] 0.02727f
C18 a_2276_11044# a_2364_11000# 0.30831f
C19 a_13700_4772# a_13788_4728# 0.30831f
C20 a_7204_1636# a_6844_1592# 0.08707f
C21 a_15380_11044# a_15468_11000# 0.30831f
C22 a_12108_2727# VDD 0.37606f
C23 a_11478_11784# VDD 0.98456f
C24 a_17708_5863# a_17620_5960# 0.30831f
C25 a_15804_15704# VDD 0.36153f
C26 a_20756_15748# a_20396_15704# 0.08717f
C27 a_12804_1256# VDD 0.2258f
C28 a_18828_1159# a_18740_1256# 0.30831f
C29 a_14236_4728# VDD 0.34473f
C30 a_2812_2727# a_3172_2824# 0.08717f
C31 a_18492_7864# a_18604_7431# 0.02634f
C32 a_10228_9096# VDD 0.23126f
C33 a_17956_4772# a_17596_4728# 0.08717f
C34 a_21988_11044# a_22076_11000# 0.30831f
C35 wire18.I a_11366_10216# 0.7611f
C36 a_10116_1636# a_10204_1592# 0.30831f
C37 a_4516_6340# VDD 0.23094f
C38 a_10764_15271# VDD 0.36161f
C39 a_12916_9476# a_13004_9432# 0.30831f
C40 a_7204_6340# a_6844_6296# 0.08707f
C41 a_14124_2727# a_14036_2824# 0.30831f
C42 a_8524_4295# VDD 0.35942f
C43 a_2724_2824# VDD 0.23014f
C44 a_10652_6296# VDD 0.34882f
C45 a_8524_13703# a_8436_13800# 0.30831f
C46 a_2276_10664# VDD 0.22866f
C47 a_21068_15271# a_21428_15368# 0.0869f
C48 a_2812_7431# a_3172_7528# 0.08717f
C49 dac_div_chain\[4\]_dff_notouch_.D a_12240_16189# 0.04751f
C50 a_10764_15271# a_10676_15368# 0.30831f
C51 a_17956_9476# a_17596_9432# 0.08717f
C52 a_10116_6340# a_10204_6296# 0.30831f
C53 ana_div_chain\[2\]_inv_notouch_.ZN VDD 0.64903f
C54 a_3620_3204# a_3260_3160# 0.08707f
C55 a_15940_16615# a_16908_16623# 0.22071f
C56 a_8076_10567# a_7988_10664# 0.30831f
C57 a_14236_1592# a_14236_1159# 0.05841f
C58 a_4940_5863# VDD 0.34876f
C59 avo[0] avo[1] 0.16991f
C60 a_14124_7431# a_14036_7528# 0.30831f
C61 a_2724_14180# a_2364_14136# 0.08707f
C62 a_10788_17316# a_10204_17272# 0.04434f
C63 input1.Z a_20732_6296# 0.04613f
C64 a_14596_7908# VDD 0.22869f
C65 a_7292_6296# a_7180_5863# 0.02634f
C66 a_10116_14180# a_10204_14136# 0.30831f
C67 a_9868_16839# a_9780_16936# 0.30831f
C68 a_6644_16936# a_6756_15748# 0.02666f
C69 a_20620_10567# a_20980_10664# 0.0869f
C70 a_15268_15748# dvo[0] 0.062f
C71 a_20980_12232# VDD 0.22827f
C72 a_20980_4392# VDD 0.22827f
C73 a_1020_7431# VDD 0.33f
C74 a_3620_7908# a_3260_7864# 0.08707f
C75 a_10316_4295# a_10228_4392# 0.30831f
C76 a_14236_6296# a_14124_5863# 0.02634f
C77 a_7292_1592# VDD 0.35817f
C78 a_20420_14180# VDD 0.65413f
C79 a_2812_11000# a_2812_10567# 0.05841f
C80 a_9220_9476# VDD 0.22864f
C81 a_21852_18407# a_21764_18504# 0.30831f
C82 a_17484_15271# VDD 0.36008f
C83 a_1380_12232# a_1380_11044# 0.05841f
C84 a_21068_4295# a_21428_4392# 0.0869f
C85 a_5300_10664# a_5412_9476# 0.02666f
C86 input2.Z a_16364_5863# 0.04791f
C87 a_22076_6296# a_21964_5863# 0.02634f
C88 a_21092_1636# VDD 0.22854f
C89 a_9532_1159# a_9892_1256# 0.08717f
C90 a_8436_13800# VDD 0.23325f
C91 a_17172_5960# VDD 0.22854f
C92 a_21092_3204# a_21180_3160# 0.30831f
C93 ana_div_chain\[2\]_dff_notouch_.CLK avo[2] 0.36395f
C94 a_18940_9432# VDD 0.35234f
C95 a_11572_2824# a_11460_1636# 0.02666f
C96 a_3708_3160# VDD 0.37719f
C97 a_932_1636# a_1020_1592# 0.30831f
C98 a_9780_18504# a_9668_17316# 0.02666f
C99 a_10316_8999# a_10228_9096# 0.30831f
C100 a_2812_14136# VDD 0.33144f
C101 a_8100_15748# a_8188_15704# 0.30831f
C102 a_11324_18407# a_11236_18504# 0.30831f
C103 a_21540_17316# a_21180_17272# 0.08717f
C104 a_15580_1159# VDD 0.35817f
C105 ana_div_chain\[4\]_dff_notouch_.Q avo[4] 0.04725f
C106 a_19052_8999# VDD 0.35643f
C107 a_9668_17316# VDD 0.22851f
C108 a_18516_2824# a_18404_1636# 0.02666f
C109 a_17508_3204# VDD 0.22881f
C110 a_13588_7528# VDD 0.22827f
C111 a_21068_8999# a_21428_9096# 0.0869f
C112 a_6732_5863# a_6644_5960# 0.30831f
C113 a_11796_16577# VDD 0.48814f
C114 a_5412_15748# VDD 0.22854f
C115 a_16612_18504# ana_div_chain\[3\]_inv_notouch_.I 0.03815f
C116 a_12444_18407# VDD 0.34531f
C117 a_21092_7908# a_21180_7864# 0.30831f
C118 a_7652_4772# VDD 0.22854f
C119 a_2276_11044# a_1916_11000# 0.08717f
C120 a_13700_4772# a_13340_4728# 0.08707f
C121 a_10788_17316# dvo[4] 0.87021f
C122 a_932_6340# a_1020_6296# 0.30831f
C123 a_15380_11044# a_15020_11000# 0.08674f
C124 a_11572_7528# a_11460_6340# 0.02666f
C125 a_6756_1636# a_6844_1592# 0.30831f
C126 a_11660_2727# VDD 0.39825f
C127 a_10032_11875# VDD 0.72429f
C128 a_20308_15748# a_20396_15704# 0.30831f
C129 a_15356_15704# VDD 0.32605f
C130 a_12356_1256# VDD 0.24653f
C131 a_18380_1159# a_18740_1256# 0.08674f
C132 a_17260_5863# a_17620_5960# 0.08707f
C133 a_9756_15704# a_9868_15271# 0.02634f
C134 a_2812_2727# a_2724_2824# 0.30831f
C135 a_13788_4728# VDD 0.34473f
C136 wire12.I avo[3] 0.33426f
C137 a_9780_9096# VDD 0.22944f
C138 a_9980_11000# a_10340_11575# 0.1547f
C139 a_17508_4772# a_17596_4728# 0.30831f
C140 a_21988_11044# a_21628_11000# 0.08663f
C141 a_10116_1636# a_9756_1592# 0.08707f
C142 a_18516_7528# a_18404_6340# 0.02666f
C143 a_4068_6340# VDD 0.23871f
C144 a_10316_15271# VDD 0.34887f
C145 a_12916_9476# a_12556_9432# 0.08717f
C146 a_13676_2727# a_14036_2824# 0.08707f
C147 a_8076_4295# VDD 0.34315f
C148 a_6756_6340# a_6844_6296# 0.30831f
C149 a_18940_11000# a_19052_10567# 0.02634f
C150 a_2276_2824# VDD 0.22866f
C151 wire18.I a_14484_10664# 0.04012f
C152 a_10204_6296# VDD 0.3462f
C153 a_8076_13703# a_8436_13800# 0.08663f
C154 a_1828_10664# VDD 0.2258f
C155 a_21068_15271# a_20980_15368# 0.30831f
C156 a_2812_7431# a_2724_7528# 0.30831f
C157 dac_div_chain\[4\]_dff_notouch_.D a_11312_15819# 0.33389f
C158 a_17508_9476# a_17596_9432# 0.30831f
C159 a_10316_15271# a_10676_15368# 0.08707f
C160 a_10116_6340# a_9756_6296# 0.08707f
C161 a_11424_11115# VDD 1.16756f
C162 a_5500_14136# a_5388_13703# 0.02634f
C163 a_3172_3204# a_3260_3160# 0.30831f
C164 a_15940_16615# a_17280_16579# 0.08109f
C165 a_7628_10567# a_7988_10664# 0.08717f
C166 dac_div_chain\[1\]_inv_notouch_.ZN wire18.I 0.03761f
C167 a_4156_5863# VDD 0.35632f
C168 a_11478_11784# avo[3] 0.85017f
C169 a_13676_7431# a_14036_7528# 0.08707f
C170 a_2276_14180# a_2364_14136# 0.30831f
C171 a_21628_17272# avo[0] 0.02684f
C172 a_14148_7908# VDD 0.22869f
C173 a_21068_16839# avo[0] 0.05694f
C174 input1.Z a_20532_10664# 0.0441f
C175 a_10228_9096# avo[3] 0.04471f
C176 a_20532_12232# a_20644_11044# 0.02666f
C177 a_10116_14180# a_9756_14136# 0.0869f
C178 a_9420_16839# a_9780_16936# 0.0869f
C179 a_20620_10567# a_20532_10664# 0.30831f
C180 a_1683_18100# uio_oe[6] 0.04649f
C181 a_7988_5960# a_8100_4772# 0.02666f
C182 a_20532_12232# VDD 0.24899f
C183 a_20532_4392# VDD 0.24899f
C184 a_18492_13703# a_18404_13800# 0.30831f
C185 a_9868_4295# a_10228_4392# 0.08707f
C186 a_3172_7908# a_3260_7864# 0.30831f
C187 a_22076_7864# VDD 0.37268f
C188 input1.Z a_20620_5863# 0.05656f
C189 a_6844_1592# VDD 0.35817f
C190 a_3260_3160# a_3260_2727# 0.05841f
C191 a_14932_5960# a_15044_4772# 0.02666f
C192 a_6396_17272# a_6284_16839# 0.02634f
C193 a_8772_9476# VDD 0.25003f
C194 a_21404_18407# a_21764_18504# 0.08663f
C195 a_16192_15011# VDD 0.72881f
C196 a_21068_4295# a_20980_4392# 0.30831f
C197 a_932_7528# VDD 0.24399f
C198 a_6956_18407# a_7507_18100# 0.03672f
C199 a_9532_1159# a_9444_1256# 0.30831f
C200 a_10340_13143# avo[2] 0.53546f
C201 a_7988_13800# VDD 0.22879f
C202 a_20644_1636# VDD 0.22854f
C203 a_10204_3160# a_10316_2727# 0.02634f
C204 a_16724_5960# VDD 0.22854f
C205 a_21092_3204# a_20732_3160# 0.0869f
C206 a_21876_5960# a_21988_4772# 0.02666f
C207 avo[4] dvo[0] 0.02916f
C208 a_8972_2727# dvo[3] 0.04737f
C209 a_18492_9432# VDD 0.34923f
C210 a_3260_3160# VDD 0.33422f
C211 a_9868_8999# a_10228_9096# 0.08707f
C212 a_2364_14136# VDD 0.32958f
C213 a_8100_15748# a_7740_15704# 0.08663f
C214 a_3260_7864# a_3260_7431# 0.05841f
C215 a_10876_18407# a_11236_18504# 0.08674f
C216 a_21092_17316# a_21180_17272# 0.30831f
C217 a_15132_1159# VDD 0.32605f
C218 a_18044_3160# a_18156_2727# 0.02634f
C219 a_17862_17744# avo[4] 0.0451f
C220 a_18604_8999# VDD 0.35143f
C221 a_9220_17316# VDD 0.22846f
C222 a_17060_3204# VDD 0.22827f
C223 a_21068_8999# a_20980_9096# 0.30831f
C224 a_13140_7528# VDD 0.22827f
C225 a_6284_5863# a_6644_5960# 0.08707f
C226 a_11256_16533# VDD 0.50017f
C227 a_4964_15748# VDD 0.22854f
C228 a_10204_7864# a_10316_7431# 0.02634f
C229 a_11772_18407# VDD 0.39498f
C230 a_7204_4772# VDD 0.22854f
C231 a_21092_7908# a_20732_7864# 0.0869f
C232 a_20980_10664# a_21092_9476# 0.02666f
C233 a_13252_4772# a_13340_4728# 0.30831f
C234 a_1828_11044# a_1916_11000# 0.30831f
C235 a_6756_1636# a_6396_1592# 0.08707f
C236 a_14932_11044# a_15020_11000# 0.30831f
C237 a_11212_2727# VDD 0.35471f
C238 a_9739_12287# VDD 0.38477f
C239 a_17260_5863# a_17172_5960# 0.30831f
C240 a_20308_15748# a_19948_15704# 0.08717f
C241 a_11684_1256# VDD 0.27487f
C242 a_14908_15704# VDD 0.35525f
C243 a_18380_1159# a_18292_1256# 0.30831f
C244 a_18044_7864# a_18156_7431# 0.02634f
C245 a_13340_4728# VDD 0.34474f
C246 a_2364_2727# a_2724_2824# 0.08717f
C247 a_17508_4772# a_17148_4728# 0.08717f
C248 a_9332_9096# VDD 0.22854f
C249 a_9668_1636# a_9756_1592# 0.30831f
C250 a_21540_11044# a_21628_11000# 0.30831f
C251 a_3620_6340# VDD 0.25323f
C252 a_12468_9476# a_12556_9432# 0.30831f
C253 a_9868_15271# VDD 0.34671f
C254 a_7628_4295# VDD 0.34315f
C255 a_6756_6340# a_6396_6296# 0.08707f
C256 a_13676_2727# a_13588_2824# 0.30831f
C257 a_1828_2824# VDD 0.2258f
C258 a_8076_13703# a_7988_13800# 0.30831f
C259 a_9756_6296# VDD 0.34391f
C260 a_1380_10664# VDD 0.2258f
C261 a_20620_15271# a_20980_15368# 0.0869f
C262 a_2364_7431# a_2724_7528# 0.08717f
C263 dac_div_chain\[4\]_dff_notouch_.D a_10900_16232# 0.13336f
C264 a_20980_15368# avo[0] 0.05755f
C265 dac_div_chain\[3\]_inv_notouch_.I dvo[4] 0.11285f
C266 a_17508_9476# a_17148_9432# 0.08717f
C267 a_10316_15271# a_10228_15368# 0.30831f
C268 a_11012_11528# VDD 2.27373f
C269 a_9668_6340# a_9756_6296# 0.30831f
C270 a_3172_3204# a_2812_3160# 0.08707f
C271 a_7628_10567# a_7540_10664# 0.30831f
C272 a_13788_1592# a_13788_1159# 0.05841f
C273 a_14768_13443# dvo[1] 0.0519f
C274 a_3708_5863# VDD 0.37719f
C275 a_10032_11875# avo[3] 0.03292f
C276 a_2276_14180# a_1916_14136# 0.08707f
C277 a_10204_14136# dac_div_chain\[3\]_inv_notouch_.ZN 0.047f
C278 a_13676_7431# a_13588_7528# 0.30831f
C279 a_13700_7908# VDD 0.22869f
C280 a_6844_6296# a_6732_5863# 0.02634f
C281 a_9668_14180# a_9756_14136# 0.30831f
C282 a_9420_16839# a_9332_16936# 0.30831f
C283 a_6196_16936# a_6308_15748# 0.02666f
C284 a_19860_4392# VDD 0.23913f
C285 a_18044_13703# a_18404_13800# 0.08663f
C286 a_9868_4295# a_9780_4392# 0.30831f
C287 a_3172_7908# a_2812_7864# 0.08707f
C288 a_21628_7864# VDD 0.34473f
C289 a_6396_1592# VDD 0.35817f
C290 a_13788_6296# a_13676_5863# 0.02634f
C291 a_2364_11000# a_2364_10567# 0.05841f
C292 a_8188_9432# VDD 0.37312f
C293 a_10204_6296# avo[3] 0.04791f
C294 a_4068_2824# a_4068_1636# 0.05841f
C295 a_21404_18407# a_21316_18504# 0.30831f
C296 a_15899_15423# VDD 0.38312f
C297 VDD dvo[1] 1.14775f
C298 a_932_12232# a_932_11044# 0.05841f
C299 a_20844_15704# avo[0] 0.04904f
C300 a_21964_7431# VDD 0.36442f
C301 a_20620_4295# a_20980_4392# 0.0869f
C302 a_4852_10664# a_4964_9476# 0.02666f
C303 a_21628_6296# a_21516_5863# 0.02634f
C304 a_9084_1159# a_9444_1256# 0.08717f
C305 a_20196_1636# VDD 0.23094f
C306 a_7540_13800# VDD 0.22897f
C307 a_16276_5960# VDD 0.23094f
C308 a_20644_3204# a_20732_3160# 0.30831f
C309 a_18044_9432# VDD 0.34714f
C310 a_2812_3160# VDD 0.33144f
C311 a_10116_17316# a_10204_17272# 0.30831f
C312 a_11124_2824# a_11012_1636# 0.02666f
C313 a_9332_18504# a_9220_17316# 0.02666f
C314 a_9868_8999# a_9780_9096# 0.30831f
C315 a_1916_14136# VDD 0.32626f
C316 a_7652_15748# a_7740_15704# 0.30831f
C317 a_14684_1159# VDD 0.32605f
C318 a_10876_18407# a_10788_18504# 0.30831f
C319 a_21092_17316# a_20732_17272# 0.08717f
C320 a_4068_7528# a_4068_6340# 0.05841f
C321 a_16612_17316# avo[4] 0.88563f
C322 a_18156_8999# VDD 0.34917f
C323 a_17956_13800# a_17956_12612# 0.05841f
C324 a_16612_3204# VDD 0.24899f
C325 a_8772_17316# VDD 0.25107f
C326 a_18068_2824# a_17956_1636# 0.02666f
C327 a_12692_7528# VDD 0.24899f
C328 a_20620_8999# a_20980_9096# 0.0869f
C329 a_10764_16839# VDD 0.3514f
C330 a_6284_5863# a_6196_5960# 0.30831f
C331 a_4516_15748# VDD 0.23094f
C332 a_20644_7908# a_20732_7864# 0.30831f
C333 a_6756_4772# VDD 0.22854f
C334 a_11324_18407# VDD 0.35946f
C335 a_13252_4772# a_12892_4728# 0.08707f
C336 a_1828_11044# a_1468_11000# 0.08717f
C337 a_6308_1636# a_6396_1592# 0.30831f
C338 a_11124_7528# a_11012_6340# 0.02666f
C339 a_10764_2727# VDD 0.3448f
C340 a_8732_11919# VDD 0.402f
C341 a_8100_9476# a_8188_9432# 0.30831f
C342 a_16812_5863# a_17172_5960# 0.08707f
C343 a_9308_15704# a_9420_15271# 0.02634f
C344 a_11236_1256# VDD 0.23421f
C345 a_14460_15704# VDD 0.35918f
C346 a_19860_15748# a_19948_15704# 0.30831f
C347 a_17565_808# a_18292_1256# 0.17109f
C348 a_12892_4728# VDD 0.34477f
C349 a_2364_2727# a_2276_2824# 0.30831f
C350 a_17060_4772# a_17148_4728# 0.30831f
C351 a_8884_9096# VDD 0.22854f
C352 a_9892_11044# a_9980_11000# 0.30831f
C353 a_18068_7528# a_17956_6340# 0.02666f
C354 a_9668_1636# a_9308_1592# 0.08707f
C355 a_21540_11044# a_21180_11000# 0.0869f
C356 a_3172_6340# VDD 0.23225f
C357 a_22076_11000# VDD 0.37268f
C358 uio_oe[3] uio_oe[2] 0.079f
C359 a_21964_12135# a_21876_12232# 0.30831f
C360 a_12468_9476# a_12108_9432# 0.08717f
C361 a_9420_15271# VDD 0.34473f
C362 a_13228_2727# a_13588_2824# 0.08707f
C363 a_7180_4295# VDD 0.34315f
C364 a_6308_6340# a_6396_6296# 0.30831f
C365 a_20603_12729# VDD 0.3682f
C366 a_18492_11000# a_18604_10567# 0.02634f
C367 a_1380_2824# VDD 0.2258f
C368 a_17956_12612# a_18044_12568# 0.30831f
C369 a_9308_6296# VDD 0.34315f
C370 a_7628_13703# a_7988_13800# 0.08717f
C371 a_17862_17744# ana_div_chain\[4\]_dff_notouch_.Q 0.78911f
C372 a_932_10664# VDD 0.24399f
C373 a_20620_15271# a_20532_15368# 0.30831f
C374 a_2364_7431# a_2276_7528# 0.30831f
C375 a_17060_9476# a_17148_9432# 0.30831f
C376 a_9868_15271# a_10228_15368# 0.08707f
C377 a_5052_14136# a_4940_13703# 0.02634f
C378 a_9668_6340# a_9308_6296# 0.08707f
C379 dac_div_chain\[4\]_inv_notouch_.I dvo[4] 0.10796f
C380 a_2724_3204# a_2812_3160# 0.30831f
C381 a_7180_10567# a_7540_10664# 0.08717f
C382 a_14280_13811# dvo[1] 0.06643f
C383 a_3260_5863# VDD 0.33424f
C384 a_1828_14180# a_1916_14136# 0.30831f
C385 ana_div_chain\[3\]_inv_notouch_.ZN dvo[0] 0.03271f
C386 a_13228_7431# a_13588_7528# 0.08707f
C387 a_13252_7908# VDD 0.22869f
C388 a_9668_14180# a_9308_14136# 0.0869f
C389 a_8972_16839# a_9332_16936# 0.0869f
C390 a_7540_5960# a_7652_4772# 0.02666f
C391 a_19948_10567# a_19860_10664# 0.30831f
C392 a_19412_4392# VDD 0.28341f
C393 a_18044_13703# a_17956_13800# 0.30831f
C394 a_21180_7864# VDD 0.34473f
C395 a_2724_7908# a_2812_7864# 0.30831f
C396 a_9420_4295# a_9780_4392# 0.08707f
C397 a_5948_1592# VDD 0.35817f
C398 a_2812_3160# a_2812_2727# 0.05841f
C399 a_7740_9432# VDD 0.34473f
C400 a_14484_5960# a_14596_4772# 0.02666f
C401 a_5948_17272# a_5836_16839# 0.02634f
C402 a_20956_18407# a_21316_18504# 0.0869f
C403 a_14892_15055# VDD 0.40093f
C404 a_21516_7431# VDD 0.34315f
C405 a_20620_4295# a_20532_4392# 0.30831f
C406 a_19748_1636# VDD 0.2357f
C407 a_20732_1592# a_20755_808# 0.02977f
C408 a_9084_1159# a_8996_1256# 0.30831f
C409 a_7092_13800# VDD 0.22827f
C410 a_20644_3204# a_20284_3160# 0.0869f
C411 a_9756_3160# a_9868_2727# 0.02634f
C412 a_15828_5960# VDD 0.22827f
C413 a_17596_9432# VDD 0.34462f
C414 a_21428_5960# a_21540_4772# 0.02666f
C415 a_10116_17316# a_9756_17272# 0.0869f
C416 a_2364_3160# VDD 0.32958f
C417 a_14336_15368# ana_div_chain\[3\]_inv_notouch_.ZN 0.32285f
C418 a_9420_8999# a_9780_9096# 0.08707f
C419 a_1468_14136# VDD 0.32605f
C420 a_7652_15748# a_7292_15704# 0.08707f
C421 a_2812_7864# a_2812_7431# 0.05841f
C422 a_14236_1159# VDD 0.32605f
C423 a_20644_17316# a_20732_17272# 0.30831f
C424 a_17596_3160# a_17708_2727# 0.02634f
C425 a_17708_8999# VDD 0.3475f
C426 a_16028_3160# VDD 0.37312f
C427 a_8188_17272# VDD 0.37312f
C428 a_20620_8999# a_20532_9096# 0.30831f
C429 a_12020_7528# VDD 0.24089f
C430 a_5836_5863# a_6196_5960# 0.08707f
C431 a_10316_16839# VDD 0.34926f
C432 a_4068_15748# VDD 0.23871f
C433 a_10876_18407# VDD 0.34767f
C434 a_13168_16189# a_12875_15865# 0.49886f
C435 a_20644_7908# a_20284_7864# 0.0869f
C436 a_6308_4772# VDD 0.22854f
C437 a_9756_7864# a_9868_7431# 0.02634f
C438 a_20532_10664# a_20644_9476# 0.02666f
C439 a_12804_4772# a_12892_4728# 0.30831f
C440 a_1380_11044# a_1468_11000# 0.30831f
C441 a_6308_1636# a_5948_1592# 0.08707f
C442 a_22076_1592# ana_vco_in 0.02969f
C443 a_10316_2727# VDD 0.34474f
C444 a_9104_11875# VDD 0.18676f
C445 a_16812_5863# a_16724_5960# 0.30831f
C446 a_10788_1256# VDD 0.22609f
C447 a_8100_9476# a_7740_9432# 0.08663f
C448 a_19860_15748# a_19500_15704# 0.08717f
C449 a_17596_7864# a_17708_7431# 0.02634f
C450 a_1916_2727# a_2276_2824# 0.08717f
C451 ana_div_chain\[4\]_inv_notouch_.I VDD 0.54465f
C452 a_12444_4728# VDD 0.35949f
C453 a_8436_9096# VDD 0.23094f
C454 a_17060_4772# a_16700_4728# 0.08717f
C455 a_9220_1636# a_9308_1592# 0.30831f
C456 a_21092_11044# a_21180_11000# 0.30831f
C457 a_2724_6340# VDD 0.23014f
C458 a_21628_11000# VDD 0.34473f
C459 a_21516_12135# a_21876_12232# 0.0869f
C460 a_15468_16839# a_15940_16615# 0.03503f
C461 a_12020_9476# a_12108_9432# 0.30831f
C462 a_8972_15271# VDD 0.34473f
C463 ana_div_chain\[3\]_inv_notouch_.I avo[4] 0.06373f
C464 a_13228_2727# a_13140_2824# 0.30831f
C465 a_6308_6340# a_5948_6296# 0.08707f
C466 a_6732_4295# VDD 0.34315f
C467 a_21876_15368# a_21764_14180# 0.02666f
C468 a_20896_13053# VDD 0.72265f
C469 a_7628_13703# a_7540_13800# 0.30831f
C470 a_17956_12612# a_17596_12568# 0.0869f
C471 a_8860_6296# VDD 0.34777f
C472 a_21964_10567# VDD 0.36442f
C473 a_1916_7431# a_2276_7528# 0.08717f
C474 a_17060_9476# a_16700_9432# 0.08717f
C475 a_9868_15271# a_9780_15368# 0.30831f
C476 a_9220_6340# a_9308_6296# 0.30831f
C477 a_11796_16577# dvo[4] 0.03006f
C478 a_2724_3204# a_2364_3160# 0.08707f
C479 a_13340_1592# a_13340_1159# 0.05841f
C480 a_7180_10567# a_7092_10664# 0.30831f
C481 a_14320_13443# dvo[1] 0.06937f
C482 a_2812_5863# VDD 0.33144f
C483 a_1828_14180# a_1468_14136# 0.08707f
C484 a_13228_7431# a_13140_7528# 0.30831f
C485 a_14336_15368# dvo[0] 0.05064f
C486 a_12804_7908# VDD 0.22869f
C487 a_6396_6296# a_6284_5863# 0.02634f
C488 a_9220_14180# a_9308_14136# 0.30831f
C489 a_8972_16839# a_8884_16936# 0.30831f
C490 a_5748_16936# a_5860_15748# 0.02666f
C491 a_19500_10567# a_19860_10664# 0.08663f
C492 a_19860_12232# VDD 0.23913f
C493 a_18964_4392# VDD 0.23661f
C494 a_17596_13703# a_17956_13800# 0.0869f
C495 a_20732_7864# VDD 0.34474f
C496 a_2724_7908# a_2364_7864# 0.08707f
C497 a_9420_4295# a_9332_4392# 0.30831f
C498 a_5500_1592# VDD 0.35818f
C499 a_13340_6296# a_13228_5863# 0.02634f
C500 a_1916_11000# a_1916_10567# 0.05841f
C501 a_7292_9432# VDD 0.34473f
C502 a_3620_2824# a_3620_1636# 0.05841f
C503 a_20956_18407# a_20868_18504# 0.30831f
C504 a_15264_15011# VDD 0.1891f
C505 a_21068_7431# VDD 0.34315f
C506 a_19300_1636# VDD 0.28063f
C507 a_8636_1159# a_8996_1256# 0.08717f
C508 a_21180_6296# a_21068_5863# 0.02634f
C509 a_6644_13800# VDD 0.22827f
C510 a_20196_3204# a_20284_3160# 0.30831f
C511 a_15380_5960# VDD 0.22827f
C512 a_17148_9432# VDD 0.34315f
C513 input2.Z a_16612_7908# 0.05125f
C514 a_10676_2824# a_10564_1636# 0.02666f
C515 a_9668_17316# a_9756_17272# 0.30831f
C516 a_1916_3160# VDD 0.32626f
C517 a_9420_8999# a_9332_9096# 0.30831f
C518 a_1020_14136# VDD 0.33f
C519 a_7204_15748# a_7292_15704# 0.30831f
C520 a_13788_1159# VDD 0.32605f
C521 a_20644_17316# a_20284_17272# 0.08717f
C522 a_3620_7528# a_3620_6340# 0.05841f
C523 a_17260_8999# VDD 0.34473f
C524 a_16352_16936# a_17915_16991# 0.41635f
C525 ana_div_chain\[4\]_inv_notouch_.ZN a_16908_16623# 0.24725f
C526 a_7740_17272# VDD 0.34473f
C527 a_17508_13800# a_17508_12612# 0.05841f
C528 a_17620_2824# a_17508_1636# 0.02666f
C529 a_15580_3160# VDD 0.34473f
C530 a_11572_7528# VDD 0.29173f
C531 a_9868_16839# VDD 0.34671f
C532 a_5836_5863# a_5748_5960# 0.30831f
C533 a_3620_15748# VDD 0.25323f
C534 a_10419_18100# VDD 0.20353f
C535 a_5860_4772# VDD 0.22854f
C536 a_20196_7908# a_20284_7864# 0.30831f
C537 a_12804_4772# a_12444_4728# 0.08707f
C538 a_1380_11044# a_1020_11000# 0.08717f
C539 a_10676_7528# a_10564_6340# 0.02666f
C540 a_5860_1636# a_5948_1592# 0.30831f
C541 a_9868_2727# VDD 0.34473f
C542 a_8176_12232# VDD 1.11772f
C543 a_14708_12612# a_14432_11875# 0.06688f
C544 a_7652_9476# a_7740_9432# 0.30831f
C545 a_16364_5863# a_16724_5960# 0.08707f
C546 a_10340_1256# VDD 0.2258f
C547 a_19412_15748# a_19500_15704# 0.30831f
C548 a_17060_18504# VDD 0.22698f
C549 a_8860_15704# a_8972_15271# 0.02634f
C550 a_11996_4728# VDD 0.34951f
C551 a_1916_2727# a_1828_2824# 0.30831f
C552 a_7988_9096# VDD 0.22827f
C553 a_16612_4772# a_16700_4728# 0.30831f
C554 a_8902_11472# a_9892_11044# 0.19579f
C555 a_21092_11044# a_20732_11000# 0.0869f
C556 a_17620_7528# a_17508_6340# 0.02666f
C557 a_9220_1636# a_8860_1592# 0.08707f
C558 a_2276_6340# VDD 0.22866f
C559 a_21180_11000# VDD 0.34473f
C560 a_21516_12135# a_21428_12232# 0.30831f
C561 a_8524_15271# VDD 0.35942f
C562 a_15848_17776# avo[4] 0.51216f
C563 a_6284_4295# VDD 0.34315f
C564 a_5860_6340# a_5948_6296# 0.30831f
C565 dac_div_chain\[1\]_inv_notouch_.I a_7764_11911# 0.03292f
C566 a_12780_2727# a_13140_2824# 0.08707f
C567 a_19596_13097# VDD 0.41317f
C568 a_18044_11000# a_18156_10567# 0.02634f
C569 a_17508_12612# a_17596_12568# 0.30831f
C570 a_7180_13703# a_7540_13800# 0.08717f
C571 a_15940_6340# VDD 0.23473f
C572 a_21516_10567# VDD 0.34315f
C573 a_1916_7431# a_1828_7528# 0.30831f
C574 a_16612_9476# a_16700_9432# 0.30831f
C575 a_9420_15271# a_9780_15368# 0.08707f
C576 a_9220_6340# a_8860_6296# 0.08707f
C577 a_11256_16533# dvo[4] 0.54611f
C578 dac_div_chain\[2\]_dff_notouch_.D VDD 0.59017f
C579 a_2276_3204# a_2364_3160# 0.30831f
C580 a_932_1636# VDD 0.24399f
C581 a_6732_10567# a_7092_10664# 0.08717f
C582 a_2364_5863# VDD 0.32958f
C583 dac_div_chain\[1\]_inv_notouch_.I dac_div_chain\[1\]_inv_notouch_.ZN 0.43824f
C584 a_10316_2727# avo[3] 0.05985f
C585 a_1380_14180# a_1468_14136# 0.30831f
C586 a_12780_7431# a_13140_7528# 0.08707f
C587 a_12356_7908# VDD 0.23164f
C588 dac_div_chain\[4\]_dff_notouch_.D VDD 0.52559f
C589 dac_div_chain\[4\]_dff_notouch_.Q a_13924_17316# 0.03927f
C590 a_9220_14180# a_8860_14136# 0.0869f
C591 a_8524_16839# a_8884_16936# 0.0869f
C592 a_19500_10567# a_19412_10664# 0.30831f
C593 a_7092_5960# a_7204_4772# 0.02666f
C594 a_19412_12232# VDD 0.28341f
C595 a_17596_13703# a_17508_13800# 0.30831f
C596 a_18516_4392# VDD 0.23398f
C597 a_2276_7908# a_2364_7864# 0.30831f
C598 a_20284_7864# VDD 0.35948f
C599 a_8972_4295# a_9332_4392# 0.08707f
C600 a_5052_1592# VDD 0.3582f
C601 a_18492_13703# ana_div_chain\[1\]_dff_notouch_.CLK 0.04323f
C602 a_8100_17316# a_8188_17272# 0.30831f
C603 a_2364_3160# a_2364_2727# 0.05841f
C604 a_15940_3204# a_16028_3160# 0.30831f
C605 a_14036_5960# a_14148_4772# 0.02666f
C606 input1.Z a_20644_7908# 0.05679f
C607 a_6844_9432# VDD 0.34473f
C608 a_5500_17272# a_5388_16839# 0.02634f
C609 a_20508_18407# a_20868_18504# 0.0869f
C610 a_8884_7528# dvo[3] 0.05679f
C611 a_19948_4295# a_19860_4392# 0.30831f
C612 a_20620_7431# VDD 0.34779f
C613 a_18852_1636# VDD 0.2354f
C614 a_8636_1159# a_8548_1256# 0.30831f
C615 a_4068_10664# a_4068_9476# 0.05841f
C616 a_6196_13800# VDD 0.22827f
C617 a_14932_5960# VDD 0.22827f
C618 a_20196_3204# a_19836_3160# 0.0869f
C619 a_9308_3160# a_9420_2727# 0.02634f
C620 a_20980_5960# a_21092_4772# 0.02666f
C621 a_16700_9432# VDD 0.34984f
C622 a_9668_17316# a_9308_17272# 0.0869f
C623 a_1468_3160# VDD 0.32605f
C624 a_8972_8999# a_9332_9096# 0.08707f
C625 dac_div_chain\[2\]_load_slew15.Z a_8008_11504# 0.20352f
C626 a_8100_14180# VDD 0.23473f
C627 a_18208_16579# a_18964_15748# 0.0368f
C628 a_7204_15748# a_6844_15704# 0.08707f
C629 a_2364_7864# a_2364_7431# 0.05841f
C630 a_9868_18407# a_9780_18504# 0.30831f
C631 a_15940_7908# a_16028_7864# 0.30831f
C632 a_13340_1159# VDD 0.32606f
C633 a_20196_17316# a_20284_17272# 0.30831f
C634 ana_div_chain\[3\]_inv_notouch_.I ana_div_chain\[3\]_inv_notouch_.ZN 0.54006f
C635 a_17148_3160# a_17260_2727# 0.02634f
C636 a_16352_16936# a_16908_16623# 0.83991f
C637 a_16812_8999# VDD 0.34473f
C638 a_7292_17272# VDD 0.34473f
C639 a_15132_3160# VDD 0.34473f
C640 a_19948_8999# a_19860_9096# 0.30831f
C641 a_11124_7528# VDD 0.23478f
C642 a_9420_16839# VDD 0.34473f
C643 a_5388_5863# a_5748_5960# 0.08707f
C644 a_3172_15748# VDD 0.23225f
C645 a_9868_18407# VDD 0.35381f
C646 a_20196_7908# a_19836_7864# 0.0869f
C647 a_5412_4772# VDD 0.22854f
C648 a_9308_7864# a_9420_7431# 0.02634f
C649 a_12356_4772# a_12444_4728# 0.30831f
C650 a_932_11044# a_1020_11000# 0.30831f
C651 a_5860_1636# a_5500_1592# 0.08707f
C652 a_9420_2727# VDD 0.34473f
C653 wire20.I a_14432_11875# 0.03245f
C654 dac_div_chain\[0\]_inv_notouch_.ZN dvo[1] 0.15847f
C655 dac_div_chain\[1\]_inv_notouch_.I avo[2] 0.12018f
C656 a_9892_1256# VDD 0.2258f
C657 a_7652_9476# a_7292_9432# 0.08707f
C658 a_16364_5863# a_16276_5960# 0.30831f
C659 a_16612_18504# VDD 0.22805f
C660 a_19412_15748# a_19052_15704# 0.08717f
C661 a_1468_2727# a_1828_2824# 0.08717f
C662 a_17148_7864# a_17260_7431# 0.02634f
C663 a_11548_4728# VDD 0.40851f
C664 a_7540_9096# VDD 0.22827f
C665 dvo[4] dvo[1] 0.16244f
C666 a_20644_11044# a_20732_11000# 0.30831f
C667 a_8772_1636# a_8860_1592# 0.30831f
C668 a_11124_9096# avo[2] 0.04471f
C669 a_1828_6340# VDD 0.2258f
C670 a_20732_11000# VDD 0.34474f
C671 a_21068_12135# a_21428_12232# 0.0869f
C672 a_11012_9476# a_11100_9432# 0.30831f
C673 a_8076_15271# VDD 0.34315f
C674 a_21428_15368# a_21316_14180# 0.02666f
C675 a_5836_4295# VDD 0.34315f
C676 a_12780_2727# a_12692_2824# 0.30831f
C677 a_5860_6340# a_5500_6296# 0.08707f
C678 a_8902_13040# a_7764_11911# 0.08019f
C679 a_19968_13053# VDD 0.18803f
C680 a_17508_12612# a_17148_12568# 0.0869f
C681 dac_div_chain\[3\]_inv_notouch_.I a_11772_14136# 0.05254f
C682 a_7180_13703# a_7092_13800# 0.30831f
C683 a_15492_6340# VDD 0.22854f
C684 a_21068_10567# VDD 0.34315f
C685 a_19724_15271# a_19636_15368# 0.30831f
C686 a_20420_14180# avo[1] 0.02975f
C687 a_1468_7431# a_1828_7528# 0.08717f
C688 a_9420_15271# a_9332_15368# 0.30831f
C689 a_8772_6340# a_8860_6296# 0.30831f
C690 a_4156_14136# a_4156_13703# 0.05841f
C691 ana_div_chain\[2\]_inv_notouch_.I a_11660_8999# 0.02975f
C692 input2.Z a_16612_11044# 0.05125f
C693 a_14880_11875# a_14776_11919# 0.10745f
C694 a_2276_3204# a_1916_3160# 0.08707f
C695 a_7740_12568# VDD 0.35492f
C696 a_12892_1592# a_12892_1159# 0.05841f
C697 a_21876_2824# VDD 0.23455f
C698 a_6732_10567# a_6644_10664# 0.30831f
C699 dac_div_chain\[1\]_inv_notouch_.ZN a_13384_11784# 0.02502f
C700 a_1916_5863# VDD 0.32626f
C701 a_1380_14180# a_1020_14136# 0.08707f
C702 a_12780_7431# a_12692_7528# 0.30831f
C703 ana_div_chain\[2\]_inv_notouch_.ZN a_11366_10216# 0.09883f
C704 a_11908_7908# VDD 0.23871f
C705 a_5948_6296# a_5836_5863# 0.02634f
C706 a_8772_14180# a_8860_14136# 0.30831f
C707 a_8524_16839# a_8436_16936# 0.30831f
C708 a_19860_12232# a_19748_11044# 0.02666f
C709 a_19052_10567# a_19412_10664# 0.08707f
C710 a_5300_16936# a_5412_15748# 0.02666f
C711 ana_div_chain\[3\]_inv_notouch_.I dvo[0] 0.1556f
C712 a_18964_12232# VDD 0.23661f
C713 a_18068_4392# VDD 0.23212f
C714 a_17148_13703# a_17508_13800# 0.0869f
C715 a_8972_4295# a_8884_4392# 0.30831f
C716 a_2276_7908# a_1916_7864# 0.08707f
C717 a_19836_7864# VDD 0.34748f
C718 a_4604_1592# VDD 0.35757f
C719 a_8100_17316# a_7740_17272# 0.08663f
C720 a_12892_6296# a_12780_5863# 0.02634f
C721 a_15940_3204# a_15580_3160# 0.08663f
C722 a_1468_11000# a_1468_10567# 0.05841f
C723 a_6396_9432# VDD 0.34473f
C724 a_3172_2824# a_3172_1636# 0.05841f
C725 a_20508_18407# a_20420_18504# 0.30831f
C726 ana_div_chain\[4\]_dff_notouch_.CLK a_15940_16615# 0.5228f
C727 a_19500_4295# a_19860_4392# 0.08663f
C728 a_19948_7431# VDD 0.37418f
C729 a_13272_13352# wire20.I 0.24914f
C730 a_18404_1636# VDD 0.23318f
C731 a_20732_6296# a_20620_5863# 0.02634f
C732 a_5748_13800# VDD 0.22827f
C733 a_19748_3204# a_19836_3160# 0.30831f
C734 a_14484_5960# VDD 0.22827f
C735 a_21988_9476# VDD 0.23471f
C736 a_9220_17316# a_9308_17272# 0.30831f
C737 a_10228_2824# a_10116_1636# 0.02666f
C738 a_1020_3160# VDD 0.33f
C739 a_8972_8999# a_8884_9096# 0.30831f
C740 a_8860_4728# dvo[3] 0.05656f
C741 a_7652_14180# VDD 0.22854f
C742 dac_div_chain\[2\]_load_slew15.Z a_7292_11000# 0.04101f
C743 a_10204_17272# a_10316_16839# 0.02634f
C744 a_6756_15748# a_6844_15704# 0.30831f
C745 a_15940_7908# a_15580_7864# 0.08663f
C746 a_9420_18407# a_9780_18504# 0.08674f
C747 a_12892_1159# VDD 0.32608f
C748 a_20196_17316# a_19836_17272# 0.08717f
C749 ana_div_chain\[0\]_dff_notouch_.D VDD 0.52391f
C750 ana_div_chain\[3\]_inv_notouch_.I a_14336_15368# 0.07076f
C751 a_3172_7528# a_3172_6340# 0.05841f
C752 a_16364_8999# VDD 0.35942f
C753 a_16352_16936# a_17280_16579# 1.16478f
C754 a_17060_13800# a_17060_12612# 0.05841f
C755 a_6844_17272# VDD 0.34473f
C756 a_14684_3160# VDD 0.34473f
C757 a_17172_2824# a_17060_1636# 0.02666f
C758 a_19500_8999# a_19860_9096# 0.08663f
C759 a_10676_7528# VDD 0.23366f
C760 a_8972_16839# VDD 0.34474f
C761 a_2724_15748# VDD 0.23014f
C762 a_5388_5863# a_5300_5960# 0.30831f
C763 a_11312_15819# a_12875_15865# 0.41635f
C764 a_9420_18407# VDD 0.34072f
C765 a_4964_4772# VDD 0.22854f
C766 a_19748_7908# a_19836_7864# 0.30831f
C767 a_19860_10664# a_19748_9476# 0.02666f
C768 a_12356_4772# a_11996_4728# 0.08707f
C769 a_10228_7528# a_10116_6340# 0.02666f
C770 a_5412_1636# a_5500_1592# 0.30831f
C771 a_8972_2727# VDD 0.34473f
C772 a_11144_12971# a_12192_13053# 0.03873f
C773 a_9444_1256# VDD 0.2258f
C774 a_15916_5863# a_16276_5960# 0.08707f
C775 a_7204_9476# a_7292_9432# 0.30831f
C776 a_15716_15748# VDD 0.23639f
C777 a_16164_18504# VDD 0.25198f
C778 a_18964_15748# a_19052_15704# 0.30831f
C779 a_1468_2727# a_1380_2824# 0.30831f
C780 a_11100_4728# VDD 0.34935f
C781 a_7092_9096# VDD 0.22827f
C782 a_17172_7528# a_17060_6340# 0.02666f
C783 a_20644_11044# a_20284_11000# 0.0869f
C784 a_1380_6340# VDD 0.2258f
C785 a_20284_11000# VDD 0.35948f
C786 a_21068_12135# a_20980_12232# 0.30831f
C787 a_11012_9476# a_10652_9432# 0.08674f
C788 input1.Z a_20644_11044# 0.0579f
C789 a_7628_15271# VDD 0.34315f
C790 a_5412_6340# a_5500_6296# 0.30831f
C791 a_5388_4295# VDD 0.34317f
C792 a_19040_12683# VDD 1.15964f
C793 a_17060_12612# a_17148_12568# 0.30831f
C794 a_17596_11000# a_17708_10567# 0.02634f
C795 input1.Z VDD 2.60159f
C796 dac_div_chain\[3\]_inv_notouch_.I a_11324_14136# 0.04021f
C797 a_15044_6340# VDD 0.22854f
C798 a_6732_13703# a_7092_13800# 0.08717f
C799 VDD dac_vco_in 0.3442f
C800 a_11100_6296# avo[2] 0.04961f
C801 a_20620_10567# VDD 0.34779f
C802 a_19276_15271# a_19636_15368# 0.08674f
C803 a_1468_7431# a_1380_7528# 0.30831f
C804 a_8972_15271# a_9332_15368# 0.08707f
C805 a_14392_12243# a_14776_11919# 1.16478f
C806 a_1828_3204# a_1916_3160# 0.30831f
C807 a_7292_12568# VDD 0.34473f
C808 a_6284_10567# a_6644_10664# 0.08717f
C809 a_8902_11472# dvo[3] 0.86359f
C810 a_21428_2824# VDD 0.22897f
C811 dac_div_chain\[1\]_inv_notouch_.I a_12640_12932# 0.03672f
C812 a_1468_5863# VDD 0.32605f
C813 a_932_14180# a_1020_14136# 0.30831f
C814 a_11012_11528# a_12780_10567# 0.05866f
C815 dac_div_chain\[4\]_dff_notouch_.Q a_13028_17316# 0.02655f
C816 a_11460_7908# VDD 0.26857f
C817 a_8076_16839# a_8436_16936# 0.0869f
C818 a_6644_5960# a_6756_4772# 0.02666f
C819 a_19052_10567# a_18964_10664# 0.30831f
C820 a_18516_12232# VDD 0.23398f
C821 a_17620_4392# VDD 0.22999f
C822 a_17148_13703# a_17060_13800# 0.30831f
C823 a_1828_7908# a_1916_7864# 0.30831f
C824 a_8524_4295# a_8884_4392# 0.08707f
C825 a_19388_7864# VDD 0.40424f
C826 a_7652_17316# a_7740_17272# 0.30831f
C827 a_4156_1592# VDD 0.33493f
C828 ana_div_chain\[3\]_inv_notouch_.I a_16612_17316# 0.78617f
C829 a_15492_3204# a_15580_3160# 0.30831f
C830 a_1916_3160# a_1916_2727# 0.05841f
C831 a_5948_9432# VDD 0.34473f
C832 a_13588_5960# a_13700_4772# 0.02666f
C833 a_5052_17272# a_4940_16839# 0.02634f
C834 a_20060_18407# a_20420_18504# 0.0869f
C835 ana_div_chain\[4\]_dff_notouch_.CLK a_15468_16839# 0.03837f
C836 a_15940_16615# ana_div_chain\[4\]_inv_notouch_.ZN 0.12823f
C837 a_19500_4295# a_19412_4392# 0.30831f
C838 a_19500_7431# VDD 0.38302f
C839 a_12780_13703# wire20.I 0.04723f
C840 a_7964_1159# a_7876_1256# 0.30831f
C841 a_3620_10664# a_3620_9476# 0.05841f
C842 a_17956_1636# VDD 0.23149f
C843 a_5300_13800# VDD 0.22827f
C844 a_8860_3160# a_8972_2727# 0.02634f
C845 a_14036_5960# VDD 0.22827f
C846 a_19748_3204# a_19388_3160# 0.08717f
C847 wire12.I avo[2] 0.14637f
C848 a_21540_9476# VDD 0.22854f
C849 a_20532_5960# a_20644_4772# 0.02666f
C850 a_9220_17316# a_8860_17272# 0.0869f
C851 a_8100_3204# VDD 0.23473f
C852 a_8524_8999# a_8884_9096# 0.08707f
C853 a_7204_14180# VDD 0.22854f
C854 a_15492_7908# a_15580_7864# 0.30831f
C855 a_1916_7864# a_1916_7431# 0.05841f
C856 a_6756_15748# a_6396_15704# 0.08707f
C857 a_9420_18407# a_9332_18504# 0.30831f
C858 a_19748_17316# a_19836_17272# 0.30831f
C859 a_12444_1159# VDD 0.33073f
C860 a_18404_13800# VDD 0.2372f
C861 a_16700_3160# a_16812_2727# 0.02634f
C862 a_15916_8999# VDD 0.35817f
C863 a_6396_17272# VDD 0.34473f
C864 a_14236_3160# VDD 0.34473f
C865 a_10228_7528# VDD 0.23126f
C866 a_19500_8999# a_19412_9096# 0.30831f
C867 a_8524_16839# VDD 0.36017f
C868 a_4940_5863# a_5300_5960# 0.08707f
C869 a_2276_15748# VDD 0.22866f
C870 a_8860_7864# a_8972_7431# 0.02634f
C871 a_10900_16232# a_12875_15865# 0.04722f
C872 a_8963_18100# VDD 0.20112f
C873 a_19748_7908# a_19388_7864# 0.08717f
C874 a_12240_16189# a_11868_16233# 0.10745f
C875 a_4516_4772# VDD 0.23094f
C876 a_11908_4772# a_11996_4728# 0.30831f
C877 a_5412_1636# a_5052_1592# 0.08707f
C878 a_8524_2727# VDD 0.35942f
C879 a_15916_5863# a_15828_5960# 0.30831f
C880 a_7204_9476# a_6844_9432# 0.08707f
C881 a_15268_15748# VDD 0.22827f
C882 a_8996_1256# VDD 0.2258f
C883 a_15492_18504# VDD 0.23749f
C884 a_16700_7864# a_16812_7431# 0.02634f
C885 a_18964_15748# a_18604_15704# 0.08717f
C886 a_10652_4728# VDD 0.34605f
C887 a_1020_2727# a_1380_2824# 0.08717f
C888 a_6644_9096# VDD 0.22827f
C889 a_20196_11044# a_20284_11000# 0.30831f
C890 ana_div_chain\[4\]_inv_notouch_.ZN a_16700_15704# 0.05079f
C891 a_19836_11000# VDD 0.34748f
C892 a_20620_12135# a_20980_12232# 0.0869f
C893 a_8772_7908# dvo[3] 0.0441f
C894 a_10564_9476# a_10652_9432# 0.30831f
C895 a_7180_15271# VDD 0.34315f
C896 a_7764_11911# a_10032_11875# 0.03873f
C897 ana_div_chain\[3\]_inv_notouch_.I ana_div_chain\[2\]_dff_notouch_.Q 0.1592f
C898 ana_div_chain\[4\]_inv_notouch_.I avo[5] 0.1511f
C899 a_5412_6340# a_5052_6296# 0.08707f
C900 a_12108_2727# a_12020_2824# 0.30831f
C901 a_4940_4295# VDD 0.34876f
C902 a_16028_4728# a_15916_4295# 0.02634f
C903 a_18628_13096# VDD 2.29565f
C904 a_19748_14180# VDD 0.23769f
C905 a_17060_12612# a_16700_12568# 0.0869f
C906 a_6732_13703# a_6644_13800# 0.30831f
C907 input1.Z a_20732_4728# 0.04613f
C908 a_14596_6340# VDD 0.22854f
C909 a_19948_10567# VDD 0.37418f
C910 a_19276_15271# a_19188_15368# 0.30831f
C911 a_1020_7431# a_1380_7528# 0.08717f
C912 a_8188_9432# a_8076_8999# 0.02634f
C913 a_8972_15271# a_8884_15368# 0.30831f
C914 a_3708_14136# a_3708_13703# 0.05841f
C915 a_14432_11875# a_14776_11919# 0.08109f
C916 a_14392_12243# a_14880_11875# 0.83991f
C917 ana_div_chain\[2\]_inv_notouch_.ZN avo[2] 0.14734f
C918 a_1828_3204# a_1468_3160# 0.08707f
C919 a_6844_12568# VDD 0.34473f
C920 wire20.I wire18.I 0.03299f
C921 a_12444_1592# a_12444_1159# 0.05841f
C922 a_20980_2824# VDD 0.22858f
C923 a_6284_10567# a_6196_10664# 0.30831f
C924 dac_div_chain\[1\]_inv_notouch_.I a_12152_12637# 0.03917f
C925 a_1020_5863# VDD 0.33f
C926 a_12108_7431# a_12020_7528# 0.30831f
C927 a_12038_17744# a_13028_17316# 0.19607f
C928 a_11012_7908# VDD 0.23503f
C929 a_5500_6296# a_5388_5863# 0.02634f
C930 a_8076_16839# a_7988_16936# 0.30831f
C931 a_19412_12232# a_19300_11044# 0.02666f
C932 a_18604_10567# a_18964_10664# 0.08707f
C933 a_4852_16936# a_4964_15748# 0.02666f
C934 a_18068_12232# VDD 0.23212f
C935 input2.Z a_16364_4295# 0.04791f
C936 a_16700_13703# a_17060_13800# 0.0869f
C937 a_17172_4392# VDD 0.22854f
C938 a_18940_7864# VDD 0.35234f
C939 a_8524_4295# a_8436_4392# 0.30831f
C940 a_1828_7908# a_1468_7864# 0.08707f
C941 a_3708_1592# VDD 0.37719f
C942 a_7652_17316# a_7292_17272# 0.08707f
C943 a_15492_3204# a_15132_3160# 0.08707f
C944 a_1020_11000# a_1020_10567# 0.05841f
C945 a_5500_9432# VDD 0.34475f
C946 dac_div_chain\[4\]_dff_notouch_.CLK a_10900_16232# 0.54477f
C947 ana_div_chain\[2\]_inv_notouch_.I VDD 0.7189f
C948 a_2724_2824# a_2724_1636# 0.05841f
C949 a_20060_18407# a_19972_18504# 0.30831f
C950 a_15940_16615# a_16352_16936# 0.72261f
C951 a_14728_14640# dvo[0] 0.09724f
C952 a_19052_4295# a_19412_4392# 0.08707f
C953 a_19052_7431# VDD 0.35643f
C954 a_7516_1159# a_7876_1256# 0.08717f
C955 a_19388_1592# a_19276_1159# 0.02634f
C956 a_12780_13703# a_12692_13800# 0.30831f
C957 a_17508_1636# VDD 0.22881f
C958 a_4852_13800# VDD 0.24963f
C959 a_13588_5960# VDD 0.22827f
C960 a_19300_3204# a_19388_3160# 0.30831f
C961 a_21092_9476# VDD 0.22854f
C962 a_8772_17316# a_8860_17272# 0.30831f
C963 a_4819_18100# uio_oe[4] 0.04421f
C964 a_7652_3204# VDD 0.22854f
C965 a_9780_2824# a_9668_1636# 0.02666f
C966 a_8524_8999# a_8436_9096# 0.30831f
C967 a_6756_14180# VDD 0.22854f
C968 a_9756_17272# a_9868_16839# 0.02634f
C969 a_6308_15748# a_6396_15704# 0.30831f
C970 a_20662_13352# a_21652_13800# 0.19579f
C971 a_15492_7908# a_15132_7864# 0.08707f
C972 dac_div_chain\[4\]_dff_notouch_.D dvo[4] 0.0288f
C973 a_11772_1159# VDD 0.41365f
C974 a_932_9476# a_1020_9432# 0.30831f
C975 a_19748_17316# a_19388_17272# 0.08717f
C976 a_17956_13800# VDD 0.22858f
C977 a_2724_7528# a_2724_6340# 0.05841f
C978 a_15468_8999# VDD 0.35817f
C979 a_5948_17272# VDD 0.34473f
C980 a_13788_3160# VDD 0.34473f
C981 a_16724_2824# a_16612_1636# 0.02666f
C982 a_19052_8999# a_19412_9096# 0.08707f
C983 a_9780_7528# VDD 0.22944f
C984 a_8076_16839# VDD 0.34324f
C985 a_1828_15748# VDD 0.2258f
C986 a_4940_5863# a_4852_5960# 0.30831f
C987 a_11312_15819# a_11868_16233# 0.83991f
C988 a_7964_18407# VDD 0.37355f
C989 a_4068_4772# VDD 0.23871f
C990 a_10900_16232# a_13168_16189# 0.03873f
C991 a_19300_7908# a_19388_7864# 0.30831f
C992 a_19412_10664# a_19300_9476# 0.02666f
C993 a_11908_4772# a_11548_4728# 0.08707f
C994 a_9780_7528# a_9668_6340# 0.02666f
C995 a_4964_1636# a_5052_1592# 0.30831f
C996 a_8076_2727# VDD 0.34315f
C997 a_10032_11875# avo[2] 0.02966f
C998 a_15468_5863# a_15828_5960# 0.08707f
C999 a_14820_15748# VDD 0.22827f
C1000 a_6756_9476# a_6844_9432# 0.30831f
C1001 a_8548_1256# VDD 0.24653f
C1002 a_18516_15748# a_18604_15704# 0.30831f
C1003 a_15044_18504# VDD 0.23129f
C1004 a_10204_4728# VDD 0.34427f
C1005 a_6196_9096# VDD 0.22827f
C1006 a_16724_7528# a_16612_6340# 0.02666f
C1007 a_20196_11044# a_19836_11000# 0.0869f
C1008 a_20620_12135# a_20532_12232# 0.30831f
C1009 a_19388_11000# VDD 0.40424f
C1010 a_6732_15271# VDD 0.34315f
C1011 a_7764_11911# a_9739_12287# 0.04722f
C1012 a_10564_9476# a_10204_9432# 0.08674f
C1013 a_4964_6340# a_5052_6296# 0.30831f
C1014 a_11660_2727# a_12020_2824# 0.08663f
C1015 a_4156_4295# VDD 0.35632f
C1016 ana_div_chain\[1\]_dff_notouch_.CLK a_16724_12232# 0.03186f
C1017 a_18044_12568# VDD 0.35949f
C1018 a_19300_14180# VDD 0.28124f
C1019 a_17148_11000# a_17260_10567# 0.02634f
C1020 a_16612_12612# a_16700_12568# 0.30831f
C1021 a_14148_6340# VDD 0.22854f
C1022 a_6284_13703# a_6644_13800# 0.08717f
C1023 a_10228_7528# avo[3] 0.04471f
C1024 a_19500_10567# VDD 0.38302f
C1025 a_18828_15271# a_19188_15368# 0.08674f
C1026 VDD avo[4] 1.08714f
C1027 a_8524_15271# a_8884_15368# 0.08707f
C1028 a_14432_11875# a_14880_11875# 0.22071f
C1029 VDD uio_oe[1] 0.32213f
C1030 a_1380_3204# a_1468_3160# 0.30831f
C1031 a_11424_11115# avo[2] 0.03009f
C1032 a_6396_12568# VDD 0.34473f
C1033 a_20532_2824# VDD 0.24969f
C1034 a_5836_10567# a_6196_10664# 0.08717f
C1035 a_22076_6296# VDD 0.37268f
C1036 input1.Z a_20620_4295# 0.05656f
C1037 dac_div_chain\[1\]_inv_notouch_.I a_12192_13053# 0.04986f
C1038 a_932_9476# VDD 0.24399f
C1039 a_11660_7431# a_12020_7528# 0.08663f
C1040 dac_div_chain\[1\]_dff_notouch_.CLK dvo[1] 0.25257f
C1041 a_10564_7908# VDD 0.23289f
C1042 a_7628_16839# a_7988_16936# 0.08717f
C1043 a_18604_10567# a_18516_10664# 0.30831f
C1044 a_6196_5960# a_6308_4772# 0.02666f
C1045 a_932_5960# VDD 0.24399f
C1046 a_17620_12232# VDD 0.22999f
C1047 a_16724_4392# VDD 0.22854f
C1048 a_8076_4295# a_8436_4392# 0.08707f
C1049 a_1380_7908# a_1468_7864# 0.30831f
C1050 a_18492_7864# VDD 0.34923f
C1051 a_7204_17316# a_7292_17272# 0.30831f
C1052 a_3260_1592# VDD 0.33422f
C1053 a_11996_6296# a_12108_5863# 0.02634f
C1054 a_1468_3160# a_1468_2727# 0.05841f
C1055 a_15044_3204# a_15132_3160# 0.30831f
C1056 a_5052_9432# VDD 0.34477f
C1057 a_13140_5960# a_13252_4772# 0.02666f
C1058 dac_div_chain\[3\]_inv_notouch_.I a_11684_14180# 0.02544f
C1059 a_10340_11575# VDD 0.54708f
C1060 a_18604_7431# VDD 0.35143f
C1061 a_19052_4295# a_18964_4392# 0.30831f
C1062 a_19836_6296# a_19948_5863# 0.02634f
C1063 a_7516_1159# a_7428_1256# 0.30831f
C1064 a_17060_1636# VDD 0.22827f
C1065 a_3172_10664# a_3172_9476# 0.05841f
C1066 a_4068_13800# VDD 0.24448f
C1067 a_13140_5960# VDD 0.22827f
C1068 a_19300_3204# a_18940_3160# 0.08717f
C1069 a_20644_9476# VDD 0.22854f
C1070 a_7204_3204# VDD 0.22854f
C1071 a_8076_8999# a_8436_9096# 0.08707f
C1072 a_6308_14180# VDD 0.22854f
C1073 a_6308_15748# a_5948_15704# 0.08707f
C1074 a_1468_7864# a_1468_7431# 0.05841f
C1075 a_15044_7908# a_15132_7864# 0.30831f
C1076 a_19300_17316# a_19388_17272# 0.30831f
C1077 a_11324_1159# VDD 0.37635f
C1078 a_10676_10664# a_10564_9476# 0.02666f
C1079 a_20896_13053# a_21516_12135# 0.03183f
C1080 a_17508_13800# VDD 0.22623f
C1081 a_15020_8999# VDD 0.35817f
C1082 a_5500_17272# VDD 0.34475f
C1083 a_13340_3160# VDD 0.34474f
C1084 a_9332_7528# VDD 0.22854f
C1085 a_19052_8999# a_18964_9096# 0.30831f
C1086 a_7628_16839# VDD 0.34324f
C1087 a_1380_15748# VDD 0.2258f
C1088 a_10900_16232# a_11868_16233# 0.22071f
C1089 a_19300_7908# a_18940_7864# 0.08717f
C1090 a_7507_18100# VDD 0.19848f
C1091 a_11312_15819# a_12240_16189# 1.16478f
C1092 a_3620_4772# VDD 0.25323f
C1093 a_11460_4772# a_11548_4728# 0.30831f
C1094 a_4964_1636# a_4604_1592# 0.08707f
C1095 ana_div_chain\[2\]_inv_notouch_.I avo[3] 0.28468f
C1096 a_7628_2727# VDD 0.34315f
C1097 a_11144_12971# a_11748_12568# 0.49886f
C1098 a_7876_1256# VDD 0.232f
C1099 a_6756_9476# a_6396_9432# 0.08707f
C1100 a_14372_15748# VDD 0.19939f
C1101 a_15468_5863# a_15380_5960# 0.30831f
C1102 a_18516_15748# a_18156_15704# 0.08717f
C1103 a_14596_18504# VDD 0.23129f
C1104 a_9756_4728# VDD 0.34387f
C1105 a_5748_9096# VDD 0.22827f
C1106 a_19748_11044# a_19836_11000# 0.30831f
C1107 a_18940_11000# VDD 0.35234f
C1108 a_6284_15271# VDD 0.34315f
C1109 a_10116_9476# a_10204_9432# 0.30831f
C1110 a_7764_11911# a_8732_11919# 0.22071f
C1111 a_11660_2727# a_11572_2824# 0.30831f
C1112 a_3708_4295# VDD 0.37719f
C1113 a_4964_6340# a_4604_6296# 0.08707f
C1114 a_7988_13800# dac_div_chain\[2\]_load_slew11.Z 0.0272f
C1115 a_15580_4728# a_15468_4295# 0.02634f
C1116 a_17596_12568# VDD 0.34462f
C1117 a_18852_14180# VDD 0.23582f
C1118 a_6284_13703# a_6196_13800# 0.30831f
C1119 a_13700_6340# VDD 0.22854f
C1120 a_19052_10567# VDD 0.35643f
C1121 a_18828_15271# a_18740_15368# 0.30831f
C1122 a_7740_9432# a_7628_8999# 0.02634f
C1123 a_8524_15271# a_8436_15368# 0.30831f
C1124 a_14432_11875# a_14392_12243# 0.72307f
C1125 a_3260_14136# a_3260_13703# 0.05841f
C1126 a_11012_11528# avo[2] 0.08783f
C1127 a_1380_3204# a_1020_3160# 0.08707f
C1128 a_5948_12568# VDD 0.34473f
C1129 a_5836_10567# a_5748_10664# 0.30831f
C1130 a_19860_2824# VDD 0.23928f
C1131 a_21628_6296# VDD 0.34473f
C1132 a_21876_10664# VDD 0.23402f
C1133 a_11660_7431# a_11572_7528# 0.30831f
C1134 a_10116_7908# VDD 0.2313f
C1135 a_10204_4728# avo[3] 0.04791f
C1136 a_5052_6296# a_4940_5863# 0.02634f
C1137 a_7628_16839# a_7540_16936# 0.30831f
C1138 a_18964_12232# a_18852_11044# 0.02666f
C1139 uio_oe[6] uio_oe[5] 0.079f
C1140 a_18156_10567# a_18516_10664# 0.08707f
C1141 a_21964_5863# VDD 0.36442f
C1142 a_17172_12232# VDD 0.22854f
C1143 a_16276_4392# VDD 0.23094f
C1144 a_18044_7864# VDD 0.34714f
C1145 a_1380_7908# a_1020_7864# 0.08707f
C1146 a_8076_4295# a_7988_4392# 0.30831f
C1147 a_7204_17316# a_6844_17272# 0.08707f
C1148 a_2812_1592# VDD 0.33144f
C1149 a_15044_3204# a_14684_3160# 0.08707f
C1150 a_4156_17272# a_4156_16839# 0.05841f
C1151 a_4604_9432# VDD 0.35949f
C1152 dac_div_chain\[3\]_inv_notouch_.I a_11236_14180# 0.08f
C1153 a_2276_2824# a_2276_1636# 0.05841f
C1154 a_19276_18407# a_19188_18504# 0.30831f
C1155 a_9980_11000# VDD 0.34735f
C1156 a_15468_16839# a_15380_16936# 0.30831f
C1157 a_18604_4295# a_18964_4392# 0.08707f
C1158 a_18156_7431# VDD 0.34917f
C1159 a_3620_13800# VDD 0.25323f
C1160 a_16612_1636# VDD 0.24899f
C1161 a_18940_1592# a_18828_1159# 0.02634f
C1162 a_7068_1159# a_7428_1256# 0.08717f
C1163 a_12692_5960# VDD 0.24899f
C1164 ana_div_chain\[4\]_dff_notouch_.Q VDD 0.62311f
C1165 a_18852_3204# a_18940_3160# 0.30831f
C1166 a_20196_9476# VDD 0.23094f
C1167 a_19860_5960# a_19748_4772# 0.02666f
C1168 a_9332_2824# a_9220_1636# 0.02666f
C1169 a_6756_3204# VDD 0.22854f
C1170 a_8076_8999# a_7988_9096# 0.30831f
C1171 a_5860_14180# VDD 0.22854f
C1172 a_9308_17272# a_9420_16839# 0.02634f
C1173 a_10564_7908# avo[3] 0.03114f
C1174 a_5860_15748# a_5948_15704# 0.30831f
C1175 a_15044_7908# a_14684_7864# 0.08707f
C1176 a_7964_18407# a_7876_18504# 0.30831f
C1177 a_19300_17316# a_18940_17272# 0.08717f
C1178 a_17060_13800# VDD 0.2258f
C1179 a_8100_4772# a_8188_4728# 0.30831f
C1180 a_10876_1159# VDD 0.36134f
C1181 a_2276_7528# a_2276_6340# 0.05841f
C1182 a_14572_8999# VDD 0.35817f
C1183 a_5052_17272# VDD 0.34477f
C1184 a_12892_3160# VDD 0.34477f
C1185 a_18604_8999# a_18964_9096# 0.08707f
C1186 a_8884_7528# VDD 0.22854f
C1187 a_7180_16839# VDD 0.34363f
C1188 a_10900_16232# a_12240_16189# 0.08109f
C1189 a_932_15748# VDD 0.24399f
C1190 a_4156_5863# a_4068_5960# 0.30831f
C1191 a_6956_18407# VDD 0.35233f
C1192 a_3172_4772# VDD 0.23225f
C1193 a_18852_7908# a_18940_7864# 0.30831f
C1194 a_18964_10664# a_18852_9476# 0.02666f
C1195 a_11460_4772# a_11100_4728# 0.08707f
C1196 a_13280_11485# a_12987_11161# 0.49886f
C1197 a_9332_7528# a_9220_6340# 0.02666f
C1198 ana_div_chain\[3\]_inv_notouch_.ZN VDD 0.39397f
C1199 a_4516_1636# a_4604_1592# 0.30831f
C1200 a_10340_11575# avo[3] 0.55945f
C1201 a_7180_2727# VDD 0.34315f
C1202 a_18068_15748# a_18156_15704# 0.30831f
C1203 a_12875_15865# VDD 0.38413f
C1204 a_15020_5863# a_15380_5960# 0.08707f
C1205 a_6308_9476# a_6396_9432# 0.30831f
C1206 a_7428_1256# VDD 0.2258f
C1207 dac_div_chain\[3\]_inv_notouch_.ZN a_9964_13487# 0.25145f
C1208 a_14148_18504# VDD 0.23129f
C1209 a_9308_4728# VDD 0.34315f
C1210 a_5300_9096# VDD 0.22827f
C1211 a_19748_11044# a_19388_11000# 0.08717f
C1212 a_18492_11000# VDD 0.34923f
C1213 a_7764_11911# a_9104_11875# 0.08109f
C1214 a_10116_9476# a_9756_9432# 0.0869f
C1215 a_5836_15271# VDD 0.34315f
C1216 a_4516_6340# a_4604_6296# 0.30831f
C1217 a_3260_4295# VDD 0.33424f
C1218 a_11212_2727# a_11572_2824# 0.08707f
C1219 a_17148_12568# VDD 0.34315f
C1220 a_16700_11000# a_16812_10567# 0.02634f
C1221 a_18404_14180# VDD 0.2336f
C1222 a_5836_13703# a_6196_13800# 0.08717f
C1223 a_13252_6340# VDD 0.22854f
C1224 a_18604_10567# VDD 0.35143f
C1225 a_18380_15271# a_18740_15368# 0.0869f
C1226 a_8076_15271# a_8436_15368# 0.08707f
C1227 a_932_2824# a_932_1636# 0.05841f
C1228 a_13988_12071# a_14392_12243# 0.41635f
C1229 dac_div_chain\[2\]_load_slew15.Z VDD 0.34179f
C1230 a_5500_12568# VDD 0.34475f
C1231 a_19412_2824# VDD 0.28453f
C1232 a_5388_10567# a_5748_10664# 0.08717f
C1233 a_21180_6296# VDD 0.34473f
C1234 input2.Z a_16724_9096# 0.03114f
C1235 a_21428_10664# VDD 0.22827f
C1236 a_11212_7431# a_11572_7528# 0.08707f
C1237 a_9668_7908# VDD 0.22831f
C1238 ana_div_chain\[4\]_dff_notouch_.Q a_19412_16936# 0.05053f
C1239 a_7180_16839# a_7540_16936# 0.08717f
C1240 a_4068_16936# a_4068_15748# 0.05841f
C1241 a_5748_5960# a_5860_4772# 0.02666f
C1242 a_1020_1159# a_932_1256# 0.30831f
C1243 a_18156_10567# a_18068_10664# 0.30831f
C1244 a_21516_5863# VDD 0.34315f
C1245 a_15828_4392# VDD 0.22827f
C1246 a_932_7528# a_932_6340# 0.05841f
C1247 a_7628_4295# a_7988_4392# 0.08707f
C1248 a_17596_7864# VDD 0.34462f
C1249 a_2364_1592# VDD 0.32958f
C1250 a_11548_6296# a_11660_5863# 0.02634f
C1251 a_6756_17316# a_6844_17272# 0.30831f
C1252 a_1020_3160# a_1020_2727# 0.05841f
C1253 a_14596_3204# a_14684_3160# 0.30831f
C1254 VDD dvo[0] 0.63791f
C1255 a_4156_9432# VDD 0.33493f
C1256 a_12692_5960# a_12804_4772# 0.02666f
C1257 a_18828_18407# a_19188_18504# 0.08663f
C1258 a_9892_11044# VDD 0.14066f
C1259 a_15020_16839# a_15380_16936# 0.08674f
C1260 a_18604_4295# a_18516_4392# 0.30831f
C1261 a_17708_7431# VDD 0.3475f
C1262 a_16028_1592# VDD 0.38588f
C1263 a_19388_6296# a_19500_5863# 0.02634f
C1264 a_2724_10664# a_2724_9476# 0.05841f
C1265 a_7068_1159# a_6980_1256# 0.30831f
C1266 a_3172_13800# VDD 0.23225f
C1267 a_12020_5960# VDD 0.24089f
C1268 a_18852_3204# a_18492_3160# 0.08717f
C1269 a_17862_17744# VDD 0.81525f
C1270 dac_div_chain\[4\]_dff_notouch_.CLK VDD 0.40595f
C1271 a_19748_9476# VDD 0.2357f
C1272 a_6308_3204# VDD 0.22854f
C1273 a_7628_8999# a_7988_9096# 0.08707f
C1274 a_5412_14180# VDD 0.22854f
C1275 a_5860_15748# a_5500_15704# 0.08707f
C1276 a_1020_7864# a_1020_7431# 0.05841f
C1277 a_14596_7908# a_14684_7864# 0.30831f
C1278 a_8100_4772# a_7740_4728# 0.08663f
C1279 a_10228_10664# a_10116_9476# 0.02666f
C1280 a_10428_1159# VDD 0.35868f
C1281 a_18852_17316# a_18940_17272# 0.30831f
C1282 a_14124_8999# VDD 0.35817f
C1283 a_4604_17272# VDD 0.35949f
C1284 a_12444_3160# VDD 0.35949f
C1285 ana_div_chain\[1\]_dff_notouch_.CLK VDD 1.08239f
C1286 a_18604_8999# a_18516_9096# 0.30831f
C1287 a_8436_7528# VDD 0.23094f
C1288 a_6732_16839# VDD 0.34363f
C1289 a_3708_5863# a_4068_5960# 0.08717f
C1290 a_7988_15368# a_8100_14180# 0.02666f
C1291 a_10900_16232# a_11312_15819# 0.72307f
C1292 a_2724_4772# VDD 0.23014f
C1293 a_18852_7908# a_18492_7864# 0.08717f
C1294 a_6508_18407# VDD 0.34072f
C1295 a_11012_4772# a_11100_4728# 0.30831f
C1296 a_14336_15368# VDD 1.12443f
C1297 a_4516_1636# a_4156_1592# 0.08707f
C1298 a_9980_11000# avo[3] 0.02595f
C1299 a_6732_2727# VDD 0.34315f
C1300 a_8188_15704# a_8076_15271# 0.02634f
C1301 a_13168_16189# VDD 0.7254f
C1302 a_18068_15748# a_17708_15704# 0.08717f
C1303 dac_div_chain\[3\]_inv_notouch_.ZN a_10336_13443# 0.03594f
C1304 a_15020_5863# a_14932_5960# 0.30831f
C1305 a_6980_1256# VDD 0.2258f
C1306 a_6308_9476# a_5948_9432# 0.08707f
C1307 a_8860_4728# VDD 0.34777f
C1308 a_13700_18504# VDD 0.23129f
C1309 a_4852_9096# VDD 0.24963f
C1310 a_8188_4728# a_8076_4295# 0.02634f
C1311 a_19300_11044# a_19388_11000# 0.30831f
C1312 a_18044_11000# VDD 0.34714f
C1313 a_9668_9476# a_9756_9432# 0.30831f
C1314 a_7764_11911# a_8176_12232# 0.72261f
C1315 a_5388_15271# VDD 0.34317f
C1316 a_11212_2727# a_11124_2824# 0.30831f
C1317 a_7540_13800# a_7652_12612# 0.02666f
C1318 a_2812_4295# VDD 0.33144f
C1319 a_4516_6340# a_4156_6296# 0.08707f
C1320 a_16700_12568# VDD 0.34872f
C1321 a_15132_4728# a_15020_4295# 0.02634f
C1322 a_17956_14180# VDD 0.23191f
C1323 a_12804_6340# VDD 0.22854f
C1324 a_5836_13703# a_5748_13800# 0.30831f
C1325 a_18156_10567# VDD 0.34917f
C1326 a_18380_15271# a_18292_15368# 0.30831f
C1327 a_8076_15271# a_7988_15368# 0.30831f
C1328 a_7292_9432# a_7180_8999# 0.02634f
C1329 a_7092_12232# VDD 0.23039f
C1330 a_2812_14136# a_2812_13703# 0.05841f
C1331 a_13988_12071# a_14432_11875# 0.04722f
C1332 a_5052_12568# VDD 0.34477f
C1333 a_5388_10567# a_5300_10664# 0.30831f
C1334 a_18964_2824# VDD 0.23731f
C1335 a_21988_1636# a_22076_1592# 0.30831f
C1336 dac_div_chain\[1\]_inv_notouch_.I a_11748_12568# 0.03789f
C1337 a_20732_6296# VDD 0.34474f
C1338 a_20980_10664# VDD 0.22827f
C1339 a_11212_7431# a_11124_7528# 0.30831f
C1340 a_9220_7908# VDD 0.22827f
C1341 a_7180_16839# a_7092_16936# 0.30831f
C1342 a_18516_12232# a_18404_11044# 0.02666f
C1343 a_17708_10567# a_18068_10664# 0.08707f
C1344 a_21068_5863# VDD 0.34315f
C1345 dac_div_chain\[2\]_dff_notouch_.D a_7764_11911# 0.15492f
C1346 a_15380_4392# VDD 0.22827f
C1347 a_7628_4295# a_7540_4392# 0.30831f
C1348 a_17148_7864# VDD 0.34315f
C1349 input2.Z a_16612_6340# 0.05125f
C1350 a_21988_6340# a_22076_6296# 0.30831f
C1351 a_1916_1592# VDD 0.32626f
C1352 a_6756_17316# a_6396_17272# 0.08707f
C1353 a_14596_3204# a_14236_3160# 0.08707f
C1354 a_3708_17272# a_3708_16839# 0.05841f
C1355 a_3708_9432# VDD 0.37719f
C1356 a_8902_11472# VDD 0.81014f
C1357 a_1828_2824# a_1828_1636# 0.05841f
C1358 a_18828_18407# a_18740_18504# 0.30831f
C1359 a_15020_16839# a_14932_16936# 0.30831f
C1360 a_17260_7431# VDD 0.34473f
C1361 a_18156_4295# a_18516_4392# 0.08707f
C1362 a_21204_15748# avo[0] 0.03479f
C1363 a_18492_1592# a_18380_1159# 0.02634f
C1364 a_15580_1592# VDD 0.32605f
C1365 a_2724_13800# VDD 0.23014f
C1366 a_6620_1159# a_6980_1256# 0.08717f
C1367 dac_div_chain\[3\]_inv_notouch_.ZN dac_div_chain\[1\]_inv_notouch_.I 0.11165f
C1368 a_18404_3204# a_18492_3160# 0.30831f
C1369 a_11572_5960# VDD 0.29173f
C1370 a_16612_17316# VDD 0.8956f
C1371 a_10676_16936# VDD 0.23575f
C1372 a_19300_9476# VDD 0.28063f
C1373 a_19412_5960# a_19300_4772# 0.02666f
C1374 a_8884_2824# a_8772_1636# 0.02666f
C1375 a_5860_3204# VDD 0.22854f
C1376 a_7628_8999# a_7540_9096# 0.30831f
C1377 a_4964_14180# VDD 0.22854f
C1378 a_8860_17272# a_8972_16839# 0.02634f
C1379 a_5412_15748# a_5500_15704# 0.30831f
C1380 a_14596_7908# a_14236_7864# 0.08707f
C1381 a_9980_1159# VDD 0.35866f
C1382 a_7652_4772# a_7740_4728# 0.30831f
C1383 a_1828_7528# a_1828_6340# 0.05841f
C1384 a_13676_8999# VDD 0.35817f
C1385 a_11996_3160# VDD 0.34951f
C1386 a_18492_13703# VDD 0.3426f
C1387 a_4156_17272# VDD 0.33493f
C1388 a_18156_8999# a_18516_9096# 0.08707f
C1389 a_7988_7528# VDD 0.22827f
C1390 a_3708_5863# a_3620_5960# 0.30831f
C1391 a_6284_16839# VDD 0.34364f
C1392 input1.Z avo[1] 0.24291f
C1393 a_6051_18100# VDD 0.20035f
C1394 a_18404_7908# a_18492_7864# 0.30831f
C1395 a_2276_4772# VDD 0.22866f
C1396 a_18516_10664# a_18404_9476# 0.02666f
C1397 a_11012_4772# a_10652_4728# 0.08707f
C1398 a_4068_1636# a_4156_1592# 0.30831f
C1399 a_8884_7528# a_8772_6340# 0.02666f
C1400 VDD uio_oe[4] 0.36796f
C1401 a_6284_2727# VDD 0.34315f
C1402 a_17620_15748# a_17708_15704# 0.30831f
C1403 a_14572_5863# a_14932_5960# 0.08707f
C1404 dac_div_chain\[3\]_inv_notouch_.ZN a_9408_13800# 0.32416f
C1405 a_6532_1256# VDD 0.2258f
C1406 a_16941_808# a_17565_808# 0.10782f
C1407 a_11868_16233# VDD 0.41081f
C1408 a_5860_9476# a_5948_9432# 0.30831f
C1409 a_15940_4772# VDD 0.23473f
C1410 a_13252_18504# VDD 0.23129f
C1411 a_4068_9096# VDD 0.24448f
C1412 a_19300_11044# a_18940_11000# 0.08717f
C1413 a_17596_11000# VDD 0.34462f
C1414 a_19948_12135# a_19860_12232# 0.30831f
C1415 a_16352_16936# ana_div_chain\[4\]_inv_notouch_.ZN 0.30503f
C1416 a_9668_9476# a_9308_9432# 0.0869f
C1417 a_4940_15271# VDD 0.34876f
C1418 a_4068_6340# a_4156_6296# 0.30831f
C1419 a_10764_2727# a_11124_2824# 0.08707f
C1420 a_2364_4295# VDD 0.32958f
C1421 a_17956_12612# VDD 0.23117f
C1422 a_4156_1592# a_4156_1159# 0.05841f
C1423 a_17508_14180# VDD 0.22923f
C1424 a_12356_6340# VDD 0.23094f
C1425 a_5388_13703# a_5748_13800# 0.08717f
C1426 a_15828_4392# a_15940_3204# 0.02666f
C1427 input1.Z a_20532_9096# 0.0441f
C1428 a_17708_10567# VDD 0.3475f
C1429 a_17932_15271# a_18292_15368# 0.0869f
C1430 ana_div_chain\[2\]_dff_notouch_.Q VDD 0.97917f
C1431 a_7628_15271# a_7988_15368# 0.08707f
C1432 a_21964_2727# a_21876_2824# 0.30831f
C1433 a_6644_12232# VDD 0.22827f
C1434 a_4604_12568# VDD 0.35949f
C1435 a_4940_10567# a_5300_10664# 0.08717f
C1436 a_18516_2824# VDD 0.23468f
C1437 a_21988_1636# a_21628_1592# 0.08663f
C1438 a_20284_6296# VDD 0.35948f
C1439 a_20532_10664# VDD 0.24899f
C1440 a_10764_7431# a_11124_7528# 0.08707f
C1441 input1.Z a_20644_6340# 0.05679f
C1442 a_8772_7908# VDD 0.24899f
C1443 avo[5] avo[4] 0.40266f
C1444 a_8884_5960# dvo[3] 0.05679f
C1445 a_4156_6296# a_4156_5863# 0.05841f
C1446 a_6732_16839# a_7092_16936# 0.08717f
C1447 a_15828_9096# a_15940_7908# 0.02666f
C1448 a_17708_10567# a_17620_10664# 0.30831f
C1449 a_3620_16936# a_3620_15748# 0.05841f
C1450 a_5300_5960# a_5412_4772# 0.02666f
C1451 a_20620_5863# VDD 0.34779f
C1452 dac_div_chain\[2\]_load_slew11.Z a_8176_12232# 0.05877f
C1453 a_14932_4392# VDD 0.22827f
C1454 a_21964_7431# a_21876_7528# 0.30831f
C1455 dac_div_chain\[3\]_inv_notouch_.I dac_div_chain\[3\]_inv_notouch_.ZN 0.30561f
C1456 a_7180_4295# a_7540_4392# 0.08707f
C1457 a_16700_7864# VDD 0.34777f
C1458 a_11100_6296# a_11212_5863# 0.02634f
C1459 a_21988_6340# a_21628_6296# 0.08663f
C1460 a_1468_1592# VDD 0.32605f
C1461 a_6308_17316# a_6396_17272# 0.30831f
C1462 a_14148_3204# a_14236_3160# 0.30831f
C1463 a_3260_9432# VDD 0.33422f
C1464 a_8008_11504# VDD 0.56196f
C1465 a_18380_18407# a_18740_18504# 0.08674f
C1466 a_14572_16839# a_14932_16936# 0.08674f
C1467 a_8902_13040# dvo[2] 0.84506f
C1468 a_16812_7431# VDD 0.34473f
C1469 a_18156_4295# a_18068_4392# 0.30831f
C1470 a_2276_10664# a_2276_9476# 0.05841f
C1471 a_18940_6296# a_19052_5863# 0.02634f
C1472 a_2276_13800# VDD 0.22866f
C1473 a_6620_1159# a_6532_1256# 0.30831f
C1474 a_15132_1592# VDD 0.32605f
C1475 a_11124_5960# VDD 0.23478f
C1476 a_18404_3204# a_18044_3160# 0.08717f
C1477 a_10228_16936# VDD 0.2319f
C1478 a_18852_9476# VDD 0.2354f
C1479 a_5412_3204# VDD 0.22854f
C1480 a_7180_8999# a_7540_9096# 0.08707f
C1481 a_4516_14180# VDD 0.23094f
C1482 a_5412_15748# a_5052_15704# 0.08707f
C1483 a_14148_7908# a_14236_7864# 0.30831f
C1484 dac_div_chain\[2\]_load_slew11.Z dac_div_chain\[2\]_dff_notouch_.D 0.36891f
C1485 a_9780_10664# a_9668_9476# 0.02666f
C1486 a_6956_18407# a_6868_18504# 0.30831f
C1487 a_9532_1159# VDD 0.35864f
C1488 a_7652_4772# a_7292_4728# 0.08707f
C1489 a_13228_8999# VDD 0.35819f
C1490 a_16612_13800# a_16612_12612# 0.05841f
C1491 a_11548_3160# VDD 0.40851f
C1492 a_3708_17272# VDD 0.37719f
C1493 a_18044_13703# VDD 0.32982f
C1494 VDD dvo[3] 2.18906f
C1495 a_18156_8999# a_18068_9096# 0.30831f
C1496 a_7540_7528# VDD 0.22827f
C1497 a_3260_5863# a_3620_5960# 0.08717f
C1498 a_7540_15368# a_7652_14180# 0.02666f
C1499 a_5836_16839# VDD 0.34357f
C1500 a_11124_7528# avo[2] 0.04471f
C1501 a_21876_16936# VDD 0.23623f
C1502 a_1828_4772# VDD 0.2258f
C1503 a_18404_7908# a_18044_7864# 0.08717f
C1504 a_5276_18407# VDD 0.35575f
C1505 a_10564_4772# a_10652_4728# 0.30831f
C1506 a_4068_1636# a_3708_1592# 0.08707f
C1507 wire18.I a_13280_11485# 0.05082f
C1508 a_5836_2727# VDD 0.34315f
C1509 a_14572_5863# a_14484_5960# 0.30831f
C1510 a_5860_9476# a_5500_9432# 0.08707f
C1511 a_6084_1256# VDD 0.2258f
C1512 a_12240_16189# VDD 0.18841f
C1513 a_7740_15704# a_7628_15271# 0.02634f
C1514 ana_div_chain\[3\]_inv_notouch_.I VDD 1.1859f
C1515 a_12804_18504# VDD 0.23114f
C1516 a_15492_4772# VDD 0.22854f
C1517 a_7740_4728# a_7628_4295# 0.02634f
C1518 a_3620_9096# VDD 0.25323f
C1519 a_18852_11044# a_18940_11000# 0.30831f
C1520 a_17148_11000# VDD 0.34315f
C1521 a_19500_12135# a_19860_12232# 0.08717f
C1522 a_9220_9476# a_9308_9432# 0.30831f
C1523 a_4156_15271# VDD 0.35632f
C1524 a_7092_13800# a_7204_12612# 0.02666f
C1525 a_10764_2727# a_10676_2824# 0.30831f
C1526 a_1916_4295# VDD 0.32626f
C1527 a_4068_6340# a_3708_6296# 0.08707f
C1528 a_17508_12612# VDD 0.22634f
C1529 a_14684_4728# a_14572_4295# 0.02634f
C1530 a_17060_14180# VDD 0.23039f
C1531 a_5388_13703# a_5300_13800# 0.30831f
C1532 a_11908_6340# VDD 0.23801f
C1533 a_17260_10567# VDD 0.34473f
C1534 a_17932_15271# a_17844_15368# 0.30831f
C1535 a_6844_9432# a_6732_8999# 0.02634f
C1536 a_7628_15271# a_7540_15368# 0.30831f
C1537 a_13140_15368# VDD 0.23112f
C1538 a_21516_2727# a_21876_2824# 0.0869f
C1539 a_6196_12232# VDD 0.22827f
C1540 a_2364_14136# a_2364_13703# 0.05841f
C1541 a_1020_4295# a_932_4392# 0.30831f
C1542 a_4156_12568# VDD 0.33493f
C1543 a_18068_2824# VDD 0.23282f
C1544 a_21540_1636# a_21628_1592# 0.30831f
C1545 a_10340_13143# ana_div_chain\[2\]_dff_notouch_.CLK 0.22523f
C1546 a_4940_10567# a_4852_10664# 0.30831f
C1547 wire12.I dvo[2] 0.25153f
C1548 a_19836_6296# VDD 0.34748f
C1549 a_19860_10664# VDD 0.23913f
C1550 a_10764_7431# a_10676_7528# 0.30831f
C1551 a_8188_7864# VDD 0.37312f
C1552 a_18068_12232# a_17956_11044# 0.02666f
C1553 a_6732_16839# a_6644_16936# 0.30831f
C1554 a_17260_10567# a_17620_10664# 0.08707f
C1555 ana_div_chain\[0\]_dff_notouch_.Q a_20896_13053# 0.32845f
C1556 a_19948_5863# VDD 0.37418f
C1557 a_21516_7431# a_21876_7528# 0.0869f
C1558 a_14484_4392# VDD 0.22827f
C1559 a_16700_13703# a_16612_13800# 0.30831f
C1560 a_1020_8999# a_932_9096# 0.30831f
C1561 a_21988_7908# VDD 0.23471f
C1562 a_7180_4295# a_7092_4392# 0.30831f
C1563 a_21540_6340# a_21628_6296# 0.30831f
C1564 a_1020_1592# VDD 0.33f
C1565 a_6308_17316# a_5948_17272# 0.08707f
C1566 a_14148_3204# a_13788_3160# 0.08707f
C1567 a_8860_3160# dvo[3] 0.05691f
C1568 a_2812_9432# VDD 0.33144f
C1569 a_12020_5960# a_11908_4772# 0.02666f
C1570 a_3260_17272# a_3260_16839# 0.05841f
C1571 a_1380_2824# a_1380_1636# 0.05841f
C1572 a_7292_11000# VDD 0.35527f
C1573 a_18380_18407# a_18292_18504# 0.30831f
C1574 a_14572_16839# a_14484_16936# 0.30831f
C1575 wire18.I a_13988_12071# 0.03559f
C1576 a_16364_7431# VDD 0.35942f
C1577 a_17708_4295# a_18068_4392# 0.08707f
C1578 a_6172_1159# a_6532_1256# 0.08717f
C1579 a_14684_1592# VDD 0.32605f
C1580 a_1828_13800# VDD 0.2258f
C1581 a_10676_5960# VDD 0.23366f
C1582 a_17956_3204# a_18044_3160# 0.30831f
C1583 ana_div_chain\[2\]_inv_notouch_.I a_11366_10216# 0.02903f
C1584 a_9780_16936# VDD 0.22944f
C1585 a_18404_9476# VDD 0.23318f
C1586 a_18964_5960# a_18852_4772# 0.02666f
C1587 a_4964_3204# VDD 0.22854f
C1588 a_7180_8999# a_7092_9096# 0.30831f
C1589 a_4068_14180# VDD 0.23871f
C1590 a_4964_15748# a_5052_15704# 0.30831f
C1591 a_14148_7908# a_13788_7864# 0.08707f
C1592 a_6508_18407# a_6868_18504# 0.08674f
C1593 dac_div_chain\[2\]_load_slew11.Z a_7740_12568# 0.06574f
C1594 a_7204_4772# a_7292_4728# 0.30831f
C1595 a_9084_1159# VDD 0.35864f
C1596 ana_div_chain\[4\]_dff_notouch_.Q avo[5] 0.03716f
C1597 a_1380_7528# a_1380_6340# 0.05841f
C1598 a_12780_8999# VDD 0.36282f
C1599 input1.Z a_20620_12135# 0.06294f
C1600 a_3260_17272# VDD 0.33422f
C1601 a_11100_3160# VDD 0.3518f
C1602 a_17596_13703# VDD 0.32738f
C1603 a_7092_7528# VDD 0.22827f
C1604 a_17708_8999# a_18068_9096# 0.08707f
C1605 a_5388_16839# VDD 0.34326f
C1606 a_3260_5863# a_3172_5960# 0.30831f
C1607 a_21428_16936# VDD 0.23048f
C1608 a_17956_7908# a_18044_7864# 0.30831f
C1609 a_4819_18100# VDD 0.20238f
C1610 a_1380_4772# VDD 0.2258f
C1611 a_18068_10664# a_17956_9476# 0.02666f
C1612 a_10564_4772# a_10204_4728# 0.08707f
C1613 a_3620_1636# a_3708_1592# 0.30831f
C1614 a_12352_11485# a_11980_11529# 0.10745f
C1615 a_15828_12612# dvo[1] 0.14113f
C1616 a_5388_2727# VDD 0.34317f
C1617 avo[4] avo[1] 0.05765f
C1618 a_5412_9476# a_5500_9432# 0.30831f
C1619 a_14124_5863# a_14484_5960# 0.08707f
C1620 a_5636_1256# VDD 0.2258f
C1621 a_15848_17776# VDD 0.56798f
C1622 a_11312_15819# VDD 1.16334f
C1623 a_16612_15748# a_16700_15704# 0.30831f
C1624 a_15044_4772# VDD 0.22854f
C1625 a_12356_18504# VDD 0.2476f
C1626 a_11100_4728# avo[2] 0.0617f
C1627 a_3172_9096# VDD 0.23225f
C1628 a_18852_11044# a_18492_11000# 0.08717f
C1629 a_21764_14180# a_21852_14136# 0.30831f
C1630 a_16700_11000# VDD 0.34872f
C1631 a_19500_12135# a_19412_12232# 0.30831f
C1632 dac_div_chain\[4\]_dff_notouch_.CLK dvo[4] 0.0469f
C1633 a_9220_9476# a_8860_9432# 0.0869f
C1634 a_3708_15271# VDD 0.37719f
C1635 a_3620_6340# a_3708_6296# 0.30831f
C1636 a_1468_4295# VDD 0.32605f
C1637 a_10316_2727# a_10676_2824# 0.08707f
C1638 a_17060_12612# VDD 0.2258f
C1639 a_16612_14180# VDD 0.25091f
C1640 a_3708_1592# a_3708_1159# 0.05841f
C1641 a_15380_4392# a_15492_3204# 0.02666f
C1642 a_11460_6340# VDD 0.26719f
C1643 a_4940_13703# a_5300_13800# 0.08717f
C1644 a_16812_10567# VDD 0.34473f
C1645 avo[3] dvo[3] 0.32495f
C1646 a_17484_15271# a_17844_15368# 0.0869f
C1647 a_7180_15271# a_7540_15368# 0.08707f
C1648 a_12692_15368# VDD 0.24926f
C1649 a_21516_2727# a_21428_2824# 0.30831f
C1650 a_5748_12232# VDD 0.22827f
C1651 a_3708_12568# VDD 0.37719f
C1652 a_21540_1636# a_21180_1592# 0.0869f
C1653 a_17620_2824# VDD 0.23035f
C1654 a_19388_6296# VDD 0.40424f
C1655 a_19412_10664# VDD 0.28341f
C1656 a_10316_7431# a_10676_7528# 0.08707f
C1657 a_7740_7864# VDD 0.34473f
C1658 a_3708_6296# a_3708_5863# 0.05841f
C1659 a_11460_7908# avo[2] 0.03114f
C1660 a_6284_16839# a_6644_16936# 0.08717f
C1661 a_15380_9096# a_15492_7908# 0.02666f
C1662 a_3172_16936# a_3172_15748# 0.05841f
C1663 a_17260_10567# a_17172_10664# 0.30831f
C1664 a_4852_5960# a_4964_4772# 0.02666f
C1665 a_19500_5863# VDD 0.38302f
C1666 a_7292_12568# a_7180_12135# 0.02634f
C1667 a_21516_7431# a_21428_7528# 0.30831f
C1668 a_14036_4392# VDD 0.22827f
C1669 a_21540_7908# VDD 0.22854f
C1670 a_6732_4295# a_7092_4392# 0.08707f
C1671 a_10652_6296# a_10764_5863# 0.02634f
C1672 a_21540_6340# a_21180_6296# 0.0869f
C1673 a_8100_1636# VDD 0.23473f
C1674 a_5860_17316# a_5948_17272# 0.30831f
C1675 a_13700_3204# a_13788_3160# 0.30831f
C1676 a_2364_9432# VDD 0.32958f
C1677 a_10228_16936# a_10116_15748# 0.02666f
C1678 a_6844_11000# VDD 0.34473f
C1679 a_17752_18101# a_18292_18504# 0.19376f
C1680 a_14124_16839# a_14484_16936# 0.0869f
C1681 a_17708_4295# a_17620_4392# 0.30831f
C1682 a_15916_7431# VDD 0.34315f
C1683 a_18492_6296# a_18604_5863# 0.02634f
C1684 a_6172_1159# a_6084_1256# 0.30831f
C1685 a_14236_1592# VDD 0.32605f
C1686 a_17596_1592# a_17565_808# 0.04137f
C1687 a_1828_10664# a_1828_9476# 0.05841f
C1688 a_1380_13800# VDD 0.2258f
C1689 a_17956_3204# a_17596_3160# 0.08717f
C1690 ana_div_chain\[2\]_inv_notouch_.I a_10764_10567# 0.05683f
C1691 a_10228_5960# VDD 0.23126f
C1692 a_9332_16936# VDD 0.22854f
C1693 a_17956_9476# VDD 0.23149f
C1694 avo[5] dvo[0] 0.0826f
C1695 a_4516_3204# VDD 0.23094f
C1696 a_6732_8999# a_7092_9096# 0.08707f
C1697 a_3620_14180# VDD 0.25323f
C1698 a_4964_15748# a_4604_15704# 0.08707f
C1699 a_13700_7908# a_13788_7864# 0.30831f
C1700 a_7652_12612# a_7740_12568# 0.30831f
C1701 a_6508_18407# a_6420_18504# 0.30831f
C1702 a_9332_10664# a_9220_9476# 0.02666f
C1703 a_7204_4772# a_6844_4728# 0.08707f
C1704 a_8636_1159# VDD 0.3626f
C1705 a_17862_17744# avo[5] 0.8952f
C1706 a_12108_8999# VDD 0.35738f
C1707 a_17148_13703# VDD 0.32605f
C1708 a_10652_3160# VDD 0.3432f
C1709 a_2812_17272# VDD 0.33144f
C1710 a_6644_7528# VDD 0.22827f
C1711 a_17708_8999# a_17620_9096# 0.30831f
C1712 a_4940_16839# VDD 0.34885f
C1713 a_7092_15368# a_7204_14180# 0.02666f
C1714 a_2812_5863# a_3172_5960# 0.08717f
C1715 a_4044_18407# VDD 0.38096f
C1716 a_20980_16936# VDD 0.23048f
C1717 a_17956_7908# a_17596_7864# 0.08717f
C1718 VDD dvo[5] 1.14449f
C1719 a_10116_4772# a_10204_4728# 0.30831f
C1720 a_3620_1636# a_3260_1592# 0.08707f
C1721 a_8772_6340# dvo[3] 0.0441f
C1722 a_14708_12612# dvo[1] 0.90067f
C1723 ana_div_chain\[2\]_dff_notouch_.Q a_13876_13639# 0.03263f
C1724 a_4940_2727# VDD 0.34876f
C1725 a_14124_5863# a_14036_5960# 0.30831f
C1726 a_5412_9476# a_5052_9432# 0.08707f
C1727 a_5188_1256# VDD 0.2258f
C1728 a_7292_15704# a_7180_15271# 0.02634f
C1729 a_10900_16232# VDD 2.27755f
C1730 a_11684_18504# VDD 0.28613f
C1731 a_15356_17272# VDD 0.34596f
C1732 a_14596_4772# VDD 0.22854f
C1733 input1.Z a_20732_3160# 0.04613f
C1734 a_7292_4728# a_7180_4295# 0.02634f
C1735 a_2724_9096# VDD 0.23014f
C1736 dac_div_chain\[4\]_dff_notouch_.Q a_13676_16839# 0.03727f
C1737 a_18404_11044# a_18492_11000# 0.30831f
C1738 a_21764_14180# a_21404_14136# 0.08674f
C1739 a_21988_11044# VDD 0.23541f
C1740 a_19052_12135# a_19412_12232# 0.08717f
C1741 a_8772_9476# a_8860_9432# 0.30831f
C1742 a_3260_15271# VDD 0.33424f
C1743 a_1020_4295# VDD 0.33f
C1744 a_6644_13800# a_6756_12612# 0.02666f
C1745 a_3620_6340# a_3260_6296# 0.08707f
C1746 a_10316_2727# a_10228_2824# 0.30831f
C1747 a_16612_12612# VDD 0.24716f
C1748 a_14236_4728# a_14124_4295# 0.02634f
C1749 a_14728_14640# VDD 0.47539f
C1750 a_4940_13703# a_4852_13800# 0.30831f
C1751 a_11012_6340# VDD 0.23503f
C1752 a_16364_10567# VDD 0.35977f
C1753 a_17484_15271# a_17396_15368# 0.30831f
C1754 a_6396_9432# a_6284_8999# 0.02634f
C1755 a_21068_15271# avo[0] 0.0467f
C1756 a_12020_15368# VDD 0.2407f
C1757 a_7180_15271# a_7092_15368# 0.30831f
C1758 a_21068_2727# a_21428_2824# 0.0869f
C1759 a_1916_14136# a_1916_13703# 0.05841f
C1760 a_5300_12232# VDD 0.22827f
C1761 input2.Z a_16364_2727# 0.04791f
C1762 a_3260_12568# VDD 0.33422f
C1763 a_22076_4728# a_21964_4295# 0.02634f
C1764 a_21092_1636# a_21180_1592# 0.30831f
C1765 a_9980_12568# a_10340_13143# 0.1547f
C1766 a_17172_2824# VDD 0.22924f
C1767 a_4156_10567# a_4068_10664# 0.30831f
C1768 a_18940_6296# VDD 0.35234f
C1769 a_18964_10664# VDD 0.23661f
C1770 a_10316_7431# a_10228_7528# 0.30831f
C1771 uio_oe[2] uio_oe[1] 0.079f
C1772 a_7292_7864# VDD 0.34473f
C1773 a_6284_16839# a_6196_16936# 0.30831f
C1774 a_17620_12232# a_17508_11044# 0.02666f
C1775 a_16812_10567# a_17172_10664# 0.08707f
C1776 a_19052_5863# VDD 0.35643f
C1777 a_16724_12232# VDD 0.15509f
C1778 a_13588_4392# VDD 0.22827f
C1779 a_21068_7431# a_21428_7528# 0.0869f
C1780 a_22076_9432# a_21964_8999# 0.02634f
C1781 a_21092_7908# VDD 0.22854f
C1782 a_6732_4295# a_6644_4392# 0.30831f
C1783 a_7652_1636# VDD 0.22854f
C1784 a_21092_6340# a_21180_6296# 0.30831f
C1785 a_5860_17316# a_5500_17272# 0.08707f
C1786 a_13700_3204# a_13340_3160# 0.08707f
C1787 a_932_4772# a_1020_4728# 0.30831f
C1788 a_1916_9432# VDD 0.32626f
C1789 a_11572_5960# a_11460_4772# 0.02666f
C1790 a_2812_17272# a_2812_16839# 0.05841f
C1791 a_6396_11000# VDD 0.34473f
C1792 ana_div_chain\[2\]_inv_notouch_.I avo[2] 0.20987f
C1793 a_14124_16839# a_14036_16936# 0.30831f
C1794 ana_div_chain\[2\]_dff_notouch_.Q dac_div_chain\[0\]_inv_notouch_.ZN 0.17092f
C1795 VDD uio_oe[7] 0.30902f
C1796 a_15468_7431# VDD 0.34315f
C1797 a_17260_4295# a_17620_4392# 0.08707f
C1798 a_5724_1159# a_6084_1256# 0.08717f
C1799 a_13788_1592# VDD 0.32605f
C1800 a_932_13800# VDD 0.24399f
C1801 a_9780_5960# VDD 0.22944f
C1802 a_17508_3204# a_17596_3160# 0.30831f
C1803 a_18516_5960# a_18404_4772# 0.02666f
C1804 a_17508_9476# VDD 0.22881f
C1805 a_8884_16936# VDD 0.22854f
C1806 a_4068_3204# VDD 0.23871f
C1807 a_6732_8999# a_6644_9096# 0.30831f
C1808 a_3172_14180# VDD 0.23225f
C1809 a_4516_15748# a_4604_15704# 0.30831f
C1810 a_13700_7908# a_13340_7864# 0.08707f
C1811 ana_div_chain\[4\]_inv_notouch_.I a_16908_16623# 0.03942f
C1812 a_7652_12612# a_7292_12568# 0.08707f
C1813 a_7964_1159# VDD 0.38697f
C1814 a_6756_4772# a_6844_4728# 0.30831f
C1815 a_16612_13800# VDD 0.15235f
C1816 a_18628_13096# a_19948_12135# 0.05905f
C1817 a_11660_8999# VDD 0.39438f
C1818 a_2364_17272# VDD 0.32958f
C1819 a_10204_3160# VDD 0.34315f
C1820 a_16700_13703# VDD 0.32802f
C1821 a_17260_8999# a_17620_9096# 0.08707f
C1822 a_6196_7528# VDD 0.22827f
C1823 a_2812_5863# a_2724_5960# 0.30831f
C1824 a_4156_16839# VDD 0.35632f
C1825 a_3596_18407# VDD 0.36761f
C1826 a_20532_16936# VDD 0.2512f
C1827 a_17508_7908# a_17596_7864# 0.30831f
C1828 a_10116_4772# a_9756_4728# 0.08707f
C1829 a_17620_10664# a_17508_9476# 0.02666f
C1830 a_3172_1636# a_3260_1592# 0.30831f
C1831 wire20.I dvo[1] 0.04145f
C1832 input2.Z a_14432_11875# 0.06628f
C1833 a_4156_2727# VDD 0.35632f
C1834 a_7507_18100# uio_oe[2] 0.04649f
C1835 a_4964_9476# a_5052_9432# 0.30831f
C1836 a_13676_5863# a_14036_5960# 0.08707f
C1837 a_4740_1256# VDD 0.24653f
C1838 a_14908_17272# VDD 0.34315f
C1839 a_10204_15704# VDD 0.36097f
C1840 a_11236_18504# VDD 0.23421f
C1841 a_14148_4772# VDD 0.22854f
C1842 a_2276_9096# VDD 0.22866f
C1843 a_10228_5960# avo[3] 0.04471f
C1844 a_18404_11044# a_18044_11000# 0.08717f
C1845 a_21316_14180# a_21404_14136# 0.30831f
C1846 a_7988_4392# a_8100_3204# 0.02666f
C1847 a_21540_11044# VDD 0.22871f
C1848 a_19052_12135# a_18964_12232# 0.30831f
C1849 a_2812_15271# VDD 0.33144f
C1850 a_3172_6340# a_3260_6296# 0.30831f
C1851 a_9868_2727# a_10228_2824# 0.08707f
C1852 input1.Z a_20620_2727# 0.05656f
C1853 a_22076_4728# VDD 0.37268f
C1854 a_15916_12568# VDD 0.37861f
C1855 a_3260_1592# a_3260_1159# 0.05841f
C1856 a_8524_13703# a_8996_13479# 0.03503f
C1857 a_14932_4392# a_15044_3204# 0.02666f
C1858 a_10564_6340# VDD 0.23289f
C1859 a_15916_10567# VDD 0.32605f
C1860 a_11572_15368# VDD 0.28773f
C1861 a_6732_15271# a_7092_15368# 0.08707f
C1862 a_932_4392# VDD 0.24399f
C1863 a_21068_2727# a_20980_2824# 0.30831f
C1864 a_7988_9096# a_8100_7908# 0.02666f
C1865 a_4852_12232# VDD 0.24963f
C1866 a_2812_12568# VDD 0.33144f
C1867 a_16724_2824# VDD 0.22901f
C1868 a_3708_10567# a_4068_10664# 0.08717f
C1869 a_21092_1636# a_20732_1592# 0.0869f
C1870 a_21876_4392# a_21988_3204# 0.02666f
C1871 a_18492_6296# VDD 0.34923f
C1872 a_18516_10664# VDD 0.23398f
C1873 a_9868_7431# a_10228_7528# 0.08707f
C1874 ana_div_chain\[3\]_inv_notouch_.I dac_div_chain\[0\]_inv_notouch_.ZN 0.0431f
C1875 a_6844_7864# VDD 0.34473f
C1876 a_3260_6296# a_3260_5863# 0.05841f
C1877 a_14932_9096# a_15044_7908# 0.02666f
C1878 a_5836_16839# a_6196_16936# 0.08717f
C1879 a_16812_10567# a_16724_10664# 0.30831f
C1880 a_2724_16936# a_2724_15748# 0.05841f
C1881 input1.Z ana_div_chain\[0\]_dff_notouch_.Q 0.05944f
C1882 a_18604_5863# VDD 0.35143f
C1883 a_6844_12568# a_6732_12135# 0.02634f
C1884 a_13140_4392# VDD 0.22827f
C1885 a_21068_7431# a_20980_7528# 0.30831f
C1886 a_20644_7908# VDD 0.22854f
C1887 a_6284_4295# a_6644_4392# 0.08707f
C1888 a_7204_1636# VDD 0.22854f
C1889 a_21092_6340# a_20732_6296# 0.0869f
C1890 a_10204_6296# a_10316_5863# 0.02634f
C1891 a_5412_17316# a_5500_17272# 0.30831f
C1892 wire18.I a_12020_9476# 0.03049f
C1893 ana_div_chain\[1\]_dff_notouch_.CLK avo[1] 0.0458f
C1894 a_14768_13443# a_14664_13487# 0.10745f
C1895 a_13252_3204# a_13340_3160# 0.30831f
C1896 a_8972_8999# dvo[3] 0.04756f
C1897 a_21876_9096# a_21988_7908# 0.02666f
C1898 a_1468_9432# VDD 0.32605f
C1899 a_9780_16936# a_9668_15748# 0.02666f
C1900 a_5948_11000# VDD 0.34473f
C1901 a_13676_16839# a_14036_16936# 0.0869f
C1902 a_8732_11919# dvo[2] 0.06241f
C1903 a_15020_7431# VDD 0.34315f
C1904 a_17260_4295# a_17172_4392# 0.30831f
C1905 a_2588_18407# a_3139_18100# 0.03672f
C1906 a_18044_6296# a_18156_5863# 0.02634f
C1907 a_13340_1592# VDD 0.32606f
C1908 a_10971_13855# a_11264_13443# 0.49886f
C1909 a_5724_1159# a_5636_1256# 0.30831f
C1910 a_1380_10664# a_1380_9476# 0.05841f
C1911 a_8996_13479# VDD 2.24757f
C1912 ana_div_chain\[3\]_inv_notouch_.ZN dac_div_chain\[1\]_dff_notouch_.CLK 0.15805f
C1913 a_8436_16936# VDD 0.23094f
C1914 a_9332_5960# VDD 0.22854f
C1915 a_17508_3204# a_17148_3160# 0.08717f
C1916 a_17060_9476# VDD 0.22827f
C1917 a_3620_3204# VDD 0.25323f
C1918 a_6284_8999# a_6644_9096# 0.08707f
C1919 a_2724_14180# VDD 0.23014f
C1920 a_4516_15748# a_4156_15704# 0.08707f
C1921 ana_div_chain\[4\]_inv_notouch_.I a_17280_16579# 0.0443f
C1922 a_7204_12612# a_7292_12568# 0.30831f
C1923 a_13252_7908# a_13340_7864# 0.30831f
C1924 a_6756_4772# a_6396_4728# 0.08707f
C1925 a_7516_1159# VDD 0.35859f
C1926 a_21740_13703# VDD 0.36185f
C1927 a_11212_8999# VDD 0.3532f
C1928 a_1916_17272# VDD 0.32626f
C1929 a_9756_3160# VDD 0.34315f
C1930 a_14664_13487# VDD 0.18676f
C1931 a_5748_7528# VDD 0.22827f
C1932 a_17260_8999# a_17172_9096# 0.30831f
C1933 a_3708_16839# VDD 0.37719f
C1934 a_2364_5863# a_2724_5960# 0.08717f
C1935 a_6644_15368# a_6756_14180# 0.02666f
C1936 a_3139_18100# VDD 0.20331f
C1937 a_14728_14640# a_14320_13443# 0.03268f
C1938 a_17508_7908# a_17148_7864# 0.08717f
C1939 a_9668_4772# a_9756_4728# 0.30831f
C1940 a_3172_1636# a_2812_1592# 0.08707f
C1941 a_3708_2727# VDD 0.37719f
C1942 a_4068_1256# VDD 0.24483f
C1943 a_4964_9476# a_4604_9432# 0.08707f
C1944 a_14460_17272# VDD 0.34315f
C1945 a_13676_5863# a_13588_5960# 0.30831f
C1946 a_10788_18504# VDD 0.25216f
C1947 a_6844_15704# a_6732_15271# 0.02634f
C1948 a_9756_15704# VDD 0.34391f
C1949 a_13700_4772# VDD 0.22854f
C1950 a_1828_9096# VDD 0.2258f
C1951 a_6844_4728# a_6732_4295# 0.02634f
C1952 a_17956_11044# a_18044_11000# 0.30831f
C1953 a_21092_11044# VDD 0.22909f
C1954 a_18604_12135# a_18964_12232# 0.08717f
C1955 a_6196_13800# a_6308_12612# 0.02666f
C1956 a_2364_15271# VDD 0.32958f
C1957 a_9868_2727# a_9780_2824# 0.30831f
C1958 ana_div_chain\[2\]_inv_notouch_.I a_11100_9432# 0.04731f
C1959 a_3172_6340# a_2812_6296# 0.08707f
C1960 a_21628_4728# VDD 0.34473f
C1961 a_13788_4728# a_13676_4295# 0.02634f
C1962 a_4156_13703# a_4068_13800# 0.30831f
C1963 a_10204_3160# avo[3] 0.04821f
C1964 a_10116_6340# VDD 0.2313f
C1965 a_15468_10567# VDD 0.32605f
C1966 a_5948_9432# a_5836_8999# 0.02634f
C1967 a_11124_15368# VDD 0.23623f
C1968 a_6732_15271# a_6644_15368# 0.30831f
C1969 a_20620_2727# a_20980_2824# 0.0869f
C1970 a_1468_14136# a_1468_13703# 0.05841f
C1971 a_21964_4295# VDD 0.36442f
C1972 a_21628_4728# a_21516_4295# 0.02634f
C1973 a_4068_12232# VDD 0.24448f
C1974 a_2364_12568# VDD 0.32958f
C1975 a_3708_10567# a_3620_10664# 0.30831f
C1976 a_20644_1636# a_20732_1592# 0.30831f
C1977 a_16276_2824# VDD 0.23219f
C1978 a_18044_6296# VDD 0.34714f
C1979 a_18068_10664# VDD 0.23212f
C1980 a_9868_7431# a_9780_7528# 0.30831f
C1981 a_6396_7864# VDD 0.34473f
C1982 a_17172_12232# a_17060_11044# 0.02666f
C1983 a_5836_16839# a_5748_16936# 0.30831f
C1984 a_16364_10567# a_16724_10664# 0.08707f
C1985 a_4068_5960# a_4068_4772# 0.05841f
C1986 a_7764_11911# dac_div_chain\[2\]_load_slew15.Z 0.52026f
C1987 input1.Z a_20662_13352# 0.06286f
C1988 a_18156_5863# VDD 0.34917f
C1989 a_20620_7431# a_20980_7528# 0.0869f
C1990 a_14320_13443# a_16612_13800# 0.08647f
C1991 a_12692_4392# VDD 0.24899f
C1992 a_6284_4295# a_6196_4392# 0.30831f
C1993 a_21628_9432# a_21516_8999# 0.02634f
C1994 a_20196_7908# VDD 0.23094f
C1995 a_5412_17316# a_5052_17272# 0.08707f
C1996 a_20644_6340# a_20732_6296# 0.30831f
C1997 a_6756_1636# VDD 0.22854f
C1998 a_14280_13811# a_14664_13487# 1.16478f
C1999 a_13252_3204# a_12892_3160# 0.08707f
C2000 a_1020_9432# VDD 0.33f
C2001 a_11124_5960# a_11012_4772# 0.02666f
C2002 a_2364_17272# a_2364_16839# 0.05841f
C2003 a_10564_6340# avo[3] 0.03114f
C2004 a_5500_11000# VDD 0.34475f
C2005 a_13676_16839# a_13588_16936# 0.30831f
C2006 a_13384_11784# a_14432_11875# 0.03873f
C2007 a_14572_7431# VDD 0.34315f
C2008 dac_div_chain\[1\]_inv_notouch_.I ana_div_chain\[2\]_dff_notouch_.CLK 0.09517f
C2009 a_16812_4295# a_17172_4392# 0.08707f
C2010 a_21964_16839# a_21876_16936# 0.30831f
C2011 a_12892_1592# VDD 0.32608f
C2012 a_5276_1159# a_5636_1256# 0.08717f
C2013 a_8524_13703# VDD 0.36918f
C2014 a_7988_16936# VDD 0.22827f
C2015 a_8884_5960# VDD 0.22854f
C2016 a_17060_3204# a_17148_3160# 0.30831f
C2017 a_16612_9476# VDD 0.25043f
C2018 a_18068_5960# a_17956_4772# 0.02666f
C2019 a_3172_3204# VDD 0.23225f
C2020 a_6284_8999# a_6196_9096# 0.30831f
C2021 a_2276_14180# VDD 0.22866f
C2022 a_13252_7908# a_12892_7864# 0.08707f
C2023 a_4068_15748# a_4156_15704# 0.30831f
C2024 a_7204_12612# a_6844_12568# 0.08707f
C2025 a_5276_18407# a_5188_18504# 0.30831f
C2026 a_7068_1159# VDD 0.35859f
C2027 a_6308_4772# a_6396_4728# 0.30831f
C2028 a_19636_15368# a_19748_14180# 0.02666f
C2029 a_10764_8999# VDD 0.351f
C2030 a_1468_17272# VDD 0.32605f
C2031 a_14768_13443# VDD 0.40187f
C2032 a_9308_3160# VDD 0.34315f
C2033 a_5300_7528# VDD 0.22827f
C2034 a_16812_8999# a_17172_9096# 0.08707f
C2035 a_3260_16839# VDD 0.33424f
C2036 a_2364_5863# a_2276_5960# 0.30831f
C2037 a_19860_16936# VDD 0.2364f
C2038 a_10116_15748# a_10204_15704# 0.30831f
C2039 a_17060_7908# a_17148_7864# 0.30831f
C2040 a_2588_18407# VDD 0.35542f
C2041 a_17172_10664# a_17060_9476# 0.02666f
C2042 a_9668_4772# a_9308_4728# 0.08707f
C2043 a_2724_1636# a_2812_1592# 0.30831f
C2044 a_3260_2727# VDD 0.33424f
C2045 a_4516_9476# a_4604_9432# 0.30831f
C2046 a_14012_17272# VDD 0.34315f
C2047 a_3620_1256# VDD 0.24986f
C2048 a_13228_5863# a_13588_5960# 0.08707f
C2049 a_9308_15704# VDD 0.34315f
C2050 a_9780_18504# VDD 0.23125f
C2051 a_13252_4772# VDD 0.22854f
C2052 a_1380_9096# VDD 0.2258f
C2053 a_17956_11044# a_17596_11000# 0.08717f
C2054 a_20420_14180# a_19836_14136# 0.04434f
C2055 a_7540_4392# a_7652_3204# 0.02666f
C2056 a_20644_11044# VDD 0.22894f
C2057 a_18604_12135# a_18516_12232# 0.30831f
C2058 a_1916_15271# VDD 0.32626f
C2059 a_2724_6340# a_2812_6296# 0.30831f
C2060 ana_div_chain\[2\]_inv_notouch_.I a_10652_9432# 0.03031f
C2061 a_21180_4728# VDD 0.34473f
C2062 a_9420_2727# a_9780_2824# 0.08707f
C2063 input2.Z a_16724_7528# 0.03114f
C2064 a_2812_1592# a_2812_1159# 0.05841f
C2065 a_3708_13703# a_4068_13800# 0.08717f
C2066 a_9668_6340# VDD 0.22831f
C2067 a_14484_4392# a_14596_3204# 0.02666f
C2068 a_15020_10567# VDD 0.32605f
C2069 a_10676_15368# VDD 0.23516f
C2070 a_6284_15271# a_6644_15368# 0.08707f
C2071 a_21516_4295# VDD 0.34315f
C2072 a_20620_2727# a_20532_2824# 0.30831f
C2073 a_7540_9096# a_7652_7908# 0.02666f
C2074 a_3620_12232# VDD 0.25323f
C2075 a_9892_12612# a_9980_12568# 0.30831f
C2076 a_1916_12568# VDD 0.32626f
C2077 a_20644_1636# a_20284_1592# 0.0869f
C2078 a_15828_2824# VDD 0.22913f
C2079 a_3260_10567# a_3620_10664# 0.08717f
C2080 a_21428_4392# a_21540_3204# 0.02666f
C2081 dvo[4] dvo[5] 0.31956f
C2082 a_17596_6296# VDD 0.34462f
C2083 a_17620_10664# VDD 0.22999f
C2084 a_9420_7431# a_9780_7528# 0.08707f
C2085 a_1011_18100# uio_oe[7] 0.04604f
C2086 a_5948_7864# VDD 0.34473f
C2087 a_2812_6296# a_2812_5863# 0.05841f
C2088 a_14484_9096# a_14596_7908# 0.02666f
C2089 a_5388_16839# a_5748_16936# 0.08717f
C2090 a_16364_10567# a_16276_10664# 0.30831f
C2091 a_2276_16936# a_2276_15748# 0.05841f
C2092 a_6396_12568# a_6284_12135# 0.02634f
C2093 a_17708_5863# VDD 0.3475f
C2094 a_12020_4392# VDD 0.24089f
C2095 a_20620_7431# a_20532_7528# 0.30831f
C2096 a_19748_7908# VDD 0.2357f
C2097 a_5836_4295# a_6196_4392# 0.08707f
C2098 a_9756_6296# a_9868_5863# 0.02634f
C2099 a_6308_1636# VDD 0.22854f
C2100 a_4964_17316# a_5052_17272# 0.30831f
C2101 a_20644_6340# a_20284_6296# 0.0869f
C2102 a_12804_3204# a_12892_3160# 0.30831f
C2103 a_14280_13811# a_14768_13443# 0.83991f
C2104 a_14320_13443# a_14664_13487# 0.08109f
C2105 a_21428_9096# a_21540_7908# 0.02666f
C2106 a_8100_9476# VDD 0.23486f
C2107 a_9332_16936# a_9220_15748# 0.02666f
C2108 a_5052_11000# VDD 0.34477f
C2109 a_13384_11784# a_13988_12071# 0.49886f
C2110 a_13228_16839# a_13588_16936# 0.0869f
C2111 a_21516_16839# a_21876_16936# 0.0869f
C2112 a_8176_12232# dvo[2] 0.05997f
C2113 a_16812_4295# a_16724_4392# 0.30831f
C2114 a_14124_7431# VDD 0.34315f
C2115 a_5276_1159# a_5188_1256# 0.30831f
C2116 a_17596_6296# a_17708_5863# 0.02634f
C2117 a_12444_1592# VDD 0.32612f
C2118 a_8076_13703# VDD 0.34315f
C2119 a_9980_11000# a_9868_10567# 0.02634f
C2120 a_8436_5960# VDD 0.23094f
C2121 a_17060_3204# a_16700_3160# 0.08717f
C2122 a_7540_16936# VDD 0.22827f
C2123 a_15692_9432# VDD 0.37833f
C2124 a_2724_3204# VDD 0.23014f
C2125 a_5836_8999# a_6196_9096# 0.08707f
C2126 a_1828_14180# VDD 0.2258f
C2127 a_12804_7908# a_12892_7864# 0.30831f
C2128 dac_div_chain\[2\]_load_slew11.Z dac_div_chain\[2\]_load_slew15.Z 0.15753f
C2129 a_4068_15748# a_3708_15704# 0.08707f
C2130 a_6756_12612# a_6844_12568# 0.30831f
C2131 a_6308_4772# a_5948_4728# 0.08707f
C2132 a_6620_1159# VDD 0.35859f
C2133 a_10316_8999# VDD 0.34802f
C2134 a_1020_17272# VDD 0.33f
C2135 a_8860_3160# VDD 0.34777f
C2136 a_14280_13811# VDD 1.11353f
C2137 a_16812_8999# a_16724_9096# 0.30831f
C2138 a_4852_7528# VDD 0.24963f
C2139 a_2812_16839# VDD 0.33144f
C2140 a_6196_15368# a_6308_14180# 0.02666f
C2141 a_1916_5863# a_2276_5960# 0.08717f
C2142 a_19412_16936# VDD 0.25141f
C2143 a_17060_7908# a_16700_7864# 0.08717f
C2144 a_2140_18407# VDD 0.34253f
C2145 a_10116_15748# a_9756_15704# 0.0869f
C2146 a_9220_4772# a_9308_4728# 0.30831f
C2147 a_2724_1636# a_2364_1592# 0.08707f
C2148 dac_div_chain\[1\]_inv_notouch_.I wire18.I 0.02599f
C2149 dac_div_chain\[2\]_dff_notouch_.D dvo[2] 0.1532f
C2150 a_2812_2727# VDD 0.33144f
C2151 a_12038_17744# dac_div_chain\[4\]_dff_notouch_.Q 0.77081f
C2152 a_13564_17272# VDD 0.34357f
C2153 a_13228_5863# a_13140_5960# 0.30831f
C2154 a_8860_15704# VDD 0.34777f
C2155 a_3172_1256# VDD 0.23225f
C2156 ana_div_chain\[2\]_dff_notouch_.Q dac_div_chain\[1\]_dff_notouch_.CLK 0.84488f
C2157 a_4516_9476# a_4156_9432# 0.08707f
C2158 a_6396_15704# a_6284_15271# 0.02634f
C2159 a_9332_18504# VDD 0.25176f
C2160 a_12804_4772# VDD 0.22854f
C2161 a_6396_4728# a_6284_4295# 0.02634f
C2162 a_17508_11044# a_17596_11000# 0.30831f
C2163 a_20196_11044# VDD 0.23094f
C2164 a_18156_12135# a_18516_12232# 0.08717f
C2165 a_1468_15271# VDD 0.32605f
C2166 a_5748_13800# a_5860_12612# 0.02666f
C2167 a_2724_6340# a_2364_6296# 0.08707f
C2168 a_20732_4728# VDD 0.34474f
C2169 a_9420_2727# a_9332_2824# 0.30831f
C2170 a_13340_4728# a_13228_4295# 0.02634f
C2171 a_3708_13703# a_3620_13800# 0.30831f
C2172 a_9220_6340# VDD 0.22827f
C2173 a_14572_10567# VDD 0.34127f
C2174 a_11424_11115# a_12987_11161# 0.41635f
C2175 a_10228_15368# VDD 0.2319f
C2176 a_5500_9432# a_5388_8999# 0.02634f
C2177 a_6284_15271# a_6196_15368# 0.30831f
C2178 a_21068_4295# VDD 0.34315f
C2179 a_1020_14136# a_1020_13703# 0.05841f
C2180 a_21180_4728# a_21068_4295# 0.02634f
C2181 a_3172_12232# VDD 0.23225f
C2182 a_1468_12568# VDD 0.32605f
C2183 a_3260_10567# a_3172_10664# 0.30831f
C2184 a_20196_1636# a_20284_1592# 0.30831f
C2185 a_15380_2824# VDD 0.22897f
C2186 wire12.I ana_div_chain\[2\]_dff_notouch_.CLK 0.21728f
C2187 a_17148_6296# VDD 0.34315f
C2188 input2.Z a_16612_4772# 0.05125f
C2189 a_17172_10664# VDD 0.22854f
C2190 a_9420_7431# a_9332_7528# 0.30831f
C2191 a_5500_7864# VDD 0.34475f
C2192 a_5388_16839# a_5300_16936# 0.30831f
C2193 a_15916_10567# a_16276_10664# 0.08707f
C2194 a_3620_5960# a_3620_4772# 0.05841f
C2195 a_7180_12135# a_7092_12232# 0.30831f
C2196 a_17260_5863# VDD 0.34473f
C2197 VDD avo[3] 2.13974f
C2198 a_11572_4392# VDD 0.29173f
C2199 a_21180_9432# a_21068_8999# 0.02634f
C2200 a_19300_7908# VDD 0.28063f
C2201 a_5836_4295# a_5748_4392# 0.30831f
C2202 a_20196_6340# a_20284_6296# 0.30831f
C2203 a_5860_1636# VDD 0.22854f
C2204 a_4964_17316# a_4604_17272# 0.08707f
C2205 a_14320_13443# a_14768_13443# 0.22071f
C2206 a_12804_3204# a_12444_3160# 0.08707f
C2207 dac_div_chain\[4\]_dff_notouch_.Q a_14036_16936# 0.0537f
C2208 a_7652_9476# VDD 0.22924f
C2209 a_1916_17272# a_1916_16839# 0.05841f
C2210 a_10676_5960# a_10564_4772# 0.02666f
C2211 a_4604_11000# VDD 0.35949f
C2212 ana_div_chain\[2\]_dff_notouch_.Q dac_div_chain\[1\]_inv_notouch_.ZN 0.20382f
C2213 a_13228_16839# a_13140_16936# 0.30831f
C2214 a_21516_16839# a_21428_16936# 0.30831f
C2215 a_16364_4295# a_16724_4392# 0.08707f
C2216 a_13676_7431# VDD 0.34315f
C2217 a_4828_1159# a_5188_1256# 0.08717f
C2218 a_11996_1592# VDD 0.36544f
C2219 a_7628_13703# VDD 0.34315f
C2220 a_16612_3204# a_16700_3160# 0.30831f
C2221 a_7988_5960# VDD 0.22827f
C2222 a_7092_16936# VDD 0.22827f
C2223 a_17620_5960# a_17508_4772# 0.02666f
C2224 a_15244_9432# VDD 0.35864f
C2225 a_2276_3204# VDD 0.22866f
C2226 a_5836_8999# a_5748_9096# 0.30831f
C2227 a_1380_14180# VDD 0.2258f
C2228 ana_div_chain\[3\]_inv_notouch_.I dac_div_chain\[1\]_dff_notouch_.CLK 0.15704f
C2229 a_3620_15748# a_3708_15704# 0.30831f
C2230 a_12804_7908# a_12444_7864# 0.08707f
C2231 a_6756_12612# a_6396_12568# 0.08707f
C2232 a_6172_1159# VDD 0.35859f
C2233 a_16611_808# a_16941_808# 0.54229f
C2234 a_5860_4772# a_5948_4728# 0.30831f
C2235 a_19188_15368# a_19300_14180# 0.02666f
C2236 ana_div_chain\[2\]_inv_notouch_.I a_10676_10664# 0.0623f
C2237 a_9868_8999# VDD 0.34671f
C2238 a_8100_17316# VDD 0.23725f
C2239 a_14320_13443# VDD 2.22595f
C2240 a_15940_3204# VDD 0.23473f
C2241 a_16364_8999# a_16724_9096# 0.08707f
C2242 a_4068_7528# VDD 0.24448f
C2243 a_2364_16839# VDD 0.32958f
C2244 a_1916_5863# a_1828_5960# 0.30831f
C2245 a_1683_18100# VDD 0.1997f
C2246 a_9668_15748# a_9756_15704# 0.30831f
C2247 a_16612_7908# a_16700_7864# 0.30831f
C2248 a_9220_4772# a_8860_4728# 0.08707f
C2249 a_16724_10664# a_16612_9476# 0.02666f
C2250 a_2276_1636# a_2364_1592# 0.30831f
C2251 a_13384_11784# wire18.I 0.25296f
C2252 a_2364_2727# VDD 0.32958f
C2253 a_12780_5863# a_13140_5960# 0.08707f
C2254 a_2724_1256# VDD 0.23014f
C2255 a_13116_17272# VDD 0.34177f
C2256 a_4068_9476# a_4156_9432# 0.30831f
C2257 a_10116_15748# VDD 0.23384f
C2258 a_7876_18504# VDD 0.25548f
C2259 a_12356_4772# VDD 0.23094f
C2260 input1.Z a_20532_7528# 0.0441f
C2261 a_17508_11044# a_17148_11000# 0.08717f
C2262 a_7092_4392# a_7204_3204# 0.02666f
C2263 a_19748_11044# VDD 0.23573f
C2264 a_18156_12135# a_18068_12232# 0.30831f
C2265 a_1020_15271# VDD 0.33f
C2266 a_2276_6340# a_2364_6296# 0.30831f
C2267 a_20284_4728# VDD 0.35948f
C2268 a_8972_2727# a_9332_2824# 0.08707f
C2269 a_932_7908# VDD 0.24399f
C2270 dac_div_chain\[3\]_inv_notouch_.I a_11264_13443# 0.25353f
C2271 a_2364_1592# a_2364_1159# 0.05841f
C2272 a_10316_8999# avo[3] 0.05714f
C2273 a_15940_1636# a_16028_1592# 0.30831f
C2274 a_14036_4392# a_14148_3204# 0.02666f
C2275 a_8772_6340# VDD 0.24899f
C2276 a_3260_13703# a_3620_13800# 0.08717f
C2277 input1.Z a_20644_4772# 0.05679f
C2278 a_8884_4392# dvo[3] 0.05679f
C2279 a_14124_10567# VDD 0.34177f
C2280 a_11012_11528# a_12987_11161# 0.04722f
C2281 ana_div_chain\[2\]_inv_notouch_.ZN a_11980_11529# 0.21711f
C2282 a_9780_15368# VDD 0.22995f
C2283 a_5836_15271# a_6196_15368# 0.08707f
C2284 a_20620_4295# VDD 0.34779f
C2285 a_19948_2727# a_19860_2824# 0.30831f
C2286 a_7092_9096# a_7204_7908# 0.02666f
C2287 a_2724_12232# VDD 0.23014f
C2288 a_1020_12568# VDD 0.33f
C2289 a_20196_1636# a_19836_1592# 0.0869f
C2290 a_2812_10567# a_3172_10664# 0.08717f
C2291 a_14932_2824# VDD 0.22897f
C2292 a_16700_6296# VDD 0.34777f
C2293 a_20980_4392# a_21092_3204# 0.02666f
C2294 a_16724_10664# VDD 0.22854f
C2295 a_8972_7431# a_9332_7528# 0.08707f
C2296 a_5052_7864# VDD 0.34477f
C2297 a_15940_6340# a_16028_6296# 0.30831f
C2298 a_2364_6296# a_2364_5863# 0.05841f
C2299 a_14036_9096# a_14148_7908# 0.02666f
C2300 a_4940_16839# a_5300_16936# 0.08717f
C2301 ana_div_chain\[4\]_dff_notouch_.Q a_18208_16579# 0.25255f
C2302 a_1828_16936# a_1828_15748# 0.05841f
C2303 a_6732_12135# a_7092_12232# 0.08674f
C2304 a_15916_10567# a_15828_10664# 0.30831f
C2305 a_5948_12568# a_5836_12135# 0.02634f
C2306 a_16812_5863# VDD 0.34473f
C2307 a_19948_7431# a_19860_7528# 0.30831f
C2308 a_11124_4392# VDD 0.23604f
C2309 a_18852_7908# VDD 0.2354f
C2310 a_5388_4295# a_5748_4392# 0.08707f
C2311 a_9308_6296# a_9420_5863# 0.02634f
C2312 a_5412_1636# VDD 0.22854f
C2313 a_20196_6340# a_19836_6296# 0.0869f
C2314 a_4516_17316# a_4604_17272# 0.30831f
C2315 a_14320_13443# a_14280_13811# 0.72307f
C2316 a_20980_9096# a_21092_7908# 0.02666f
C2317 a_12356_3204# a_12444_3160# 0.30831f
C2318 a_8884_16936# a_8772_15748# 0.02666f
C2319 a_7204_9476# VDD 0.22854f
C2320 a_4156_11000# VDD 0.33494f
C2321 ana_div_chain\[2\]_dff_notouch_.CLK a_10032_11875# 0.06444f
C2322 a_21068_16839# a_21428_16936# 0.0869f
C2323 a_13228_7431# VDD 0.34317f
C2324 a_16364_4295# a_16276_4392# 0.30831f
C2325 dac_div_chain\[1\]_inv_notouch_.I a_11144_12971# 0.29243f
C2326 a_17148_6296# a_17260_5863# 0.02634f
C2327 a_7180_13703# VDD 0.34315f
C2328 a_9408_13800# a_10971_13855# 0.41635f
C2329 a_10336_13443# a_9964_13487# 0.10745f
C2330 a_11548_1592# VDD 0.42421f
C2331 a_4828_1159# a_4740_1256# 0.30831f
C2332 a_7540_5960# VDD 0.22827f
C2333 a_6644_16936# VDD 0.22827f
C2334 a_11124_5960# avo[2] 0.05046f
C2335 a_14796_9432# VDD 0.35864f
C2336 a_1828_3204# VDD 0.2258f
C2337 a_5388_8999# a_5748_9096# 0.08707f
C2338 a_932_14180# VDD 0.24399f
C2339 a_3620_15748# a_3260_15704# 0.08707f
C2340 a_19188_18504# a_19300_17316# 0.02666f
C2341 a_12356_7908# a_12444_7864# 0.30831f
C2342 a_4044_18407# a_3956_18504# 0.30831f
C2343 a_6308_12612# a_6396_12568# 0.30831f
C2344 a_5724_1159# VDD 0.35859f
C2345 a_5860_4772# a_5500_4728# 0.08707f
C2346 a_18044_12568# a_18156_12135# 0.02634f
C2347 a_9420_8999# VDD 0.34473f
C2348 a_7652_17316# VDD 0.23087f
C2349 a_13876_13639# VDD 0.37902f
C2350 a_15492_3204# VDD 0.22854f
C2351 a_3620_7528# VDD 0.25323f
C2352 a_16364_8999# a_16276_9096# 0.30831f
C2353 a_1916_16839# VDD 0.32626f
C2354 a_5748_15368# a_5860_14180# 0.02666f
C2355 a_1468_5863# a_1828_5960# 0.08717f
C2356 a_9668_15748# a_9308_15704# 0.0869f
C2357 a_1011_18100# VDD 0.2026f
C2358 a_17752_18101# ana_div_chain\[4\]_inv_notouch_.I 0.20276f
C2359 a_8772_4772# a_8860_4728# 0.30831f
C2360 a_2276_1636# a_1916_1592# 0.08707f
C2361 a_1916_2727# VDD 0.32626f
C2362 a_10204_17272# VDD 0.35623f
C2363 a_9668_15748# VDD 0.22831f
C2364 a_2276_1256# VDD 0.22866f
C2365 a_4068_9476# a_3708_9432# 0.08707f
C2366 a_12780_5863# a_12692_5960# 0.30831f
C2367 a_13140_15368# a_13028_14180# 0.02666f
C2368 a_11908_4772# VDD 0.23801f
C2369 a_5948_15704# a_5836_15271# 0.02634f
C2370 a_6868_18504# VDD 0.23105f
C2371 a_5948_4728# a_5836_4295# 0.02634f
C2372 a_17060_11044# a_17148_11000# 0.30831f
C2373 dac_div_chain\[2\]_load_slew11.Z a_8008_11504# 0.05432f
C2374 a_17708_12135# a_18068_12232# 0.08717f
C2375 a_19300_11044# VDD 0.28117f
C2376 a_19836_4728# VDD 0.34748f
C2377 a_5300_13800# a_5412_12612# 0.02666f
C2378 a_8972_2727# a_8884_2824# 0.30831f
C2379 a_2276_6340# a_1916_6296# 0.08707f
C2380 a_15804_15704# a_13924_15047# 0.03099f
C2381 a_12892_4728# a_12780_4295# 0.02634f
C2382 a_21876_9096# VDD 0.23402f
C2383 input1.Z a_20755_808# 0.22084f
C2384 a_21316_14180# avo[0] 0.08267f
C2385 a_15940_1636# a_15580_1592# 0.08663f
C2386 a_8188_6296# VDD 0.37312f
C2387 a_3260_13703# a_3172_13800# 0.30831f
C2388 dac_div_chain\[0\]_inv_notouch_.ZN a_14768_13443# 0.24105f
C2389 a_13676_10567# VDD 0.35801f
C2390 a_11424_11115# a_11980_11529# 0.83991f
C2391 a_11012_11528# a_13280_11485# 0.03873f
C2392 wire18.I ana_div_chain\[2\]_inv_notouch_.ZN 0.05044f
C2393 a_5052_9432# a_4940_8999# 0.02634f
C2394 a_9332_15368# VDD 0.22924f
C2395 a_5836_15271# a_5748_15368# 0.30831f
C2396 a_19948_4295# VDD 0.37418f
C2397 a_19500_2727# a_19860_2824# 0.08663f
C2398 a_2276_12232# VDD 0.22866f
C2399 a_20732_4728# a_20620_4295# 0.02634f
C2400 a_14484_2824# VDD 0.22897f
C2401 a_2812_10567# a_2724_10664# 0.30831f
C2402 a_19748_1636# a_19836_1592# 0.30831f
C2403 a_21988_6340# VDD 0.23471f
C2404 dac_div_chain\[2\]_load_slew11.Z dvo[3] 0.12475f
C2405 a_16276_10664# VDD 0.23094f
C2406 a_8972_7431# a_8884_7528# 0.30831f
C2407 a_4604_7864# VDD 0.35949f
C2408 a_8860_1592# dvo[3] 0.06707f
C2409 a_15940_6340# a_15580_6296# 0.08663f
C2410 a_4940_16839# a_4852_16936# 0.30831f
C2411 a_6732_12135# a_6644_12232# 0.30831f
C2412 a_15468_10567# a_15828_10664# 0.08707f
C2413 a_3172_5960# a_3172_4772# 0.05841f
C2414 a_16364_5863# VDD 0.35942f
C2415 a_8100_14180# a_8188_14136# 0.30831f
C2416 a_19500_7431# a_19860_7528# 0.08663f
C2417 dac_div_chain\[0\]_inv_notouch_.ZN VDD 0.63132f
C2418 a_10676_4392# VDD 0.22854f
C2419 a_5388_4295# a_5300_4392# 0.30831f
C2420 a_18404_7908# VDD 0.23318f
C2421 a_20732_9432# a_20620_8999# 0.02634f
C2422 a_4964_1636# VDD 0.22854f
C2423 a_4516_17316# a_4156_17272# 0.08707f
C2424 a_19748_6340# a_19836_6296# 0.30831f
C2425 VDD dvo[4] 1.43069f
C2426 a_13876_13639# a_14280_13811# 0.41635f
C2427 a_12356_3204# a_11996_3160# 0.08707f
C2428 a_10228_5960# a_10116_4772# 0.02666f
C2429 a_1468_17272# a_1468_16839# 0.05841f
C2430 a_6756_9476# VDD 0.22854f
C2431 a_3708_11000# VDD 0.37719f
C2432 a_21068_16839# a_20980_16936# 0.30831f
C2433 a_10340_13143# a_10032_11875# 0.0263f
C2434 a_12780_7431# VDD 0.3478f
C2435 dac_div_chain\[1\]_inv_notouch_.I a_9892_12612# 0.02724f
C2436 a_15916_4295# a_16276_4392# 0.08707f
C2437 a_6732_13703# VDD 0.34315f
C2438 a_9408_13800# a_9964_13487# 0.83991f
C2439 a_11100_1592# VDD 0.36681f
C2440 a_7092_5960# VDD 0.22827f
C2441 a_6196_16936# VDD 0.22827f
C2442 a_14348_9432# VDD 0.35864f
C2443 a_17172_5960# a_17060_4772# 0.02666f
C2444 a_1380_3204# VDD 0.2258f
C2445 a_5388_8999# a_5300_9096# 0.30831f
C2446 a_7092_12232# a_7204_11044# 0.02666f
C2447 a_3172_15748# a_3260_15704# 0.30831f
C2448 a_12356_7908# a_11996_7864# 0.08707f
C2449 ana_div_chain\[1\]_inv_notouch_.ZN VDD 0.43288f
C2450 a_3596_18407# a_3956_18504# 0.08674f
C2451 a_6308_12612# a_5948_12568# 0.08707f
C2452 a_15580_1159# a_15492_1256# 0.30831f
C2453 a_5412_4772# a_5500_4728# 0.30831f
C2454 a_5276_1159# VDD 0.35861f
C2455 a_18740_15368# a_18852_14180# 0.02666f
C2456 a_8972_8999# VDD 0.34473f
C2457 a_7204_17316# VDD 0.23055f
C2458 a_15044_3204# VDD 0.22854f
C2459 a_3172_7528# VDD 0.23225f
C2460 a_15916_8999# a_16276_9096# 0.08707f
C2461 a_1468_16839# VDD 0.32605f
C2462 a_15268_17316# a_15356_17272# 0.30831f
C2463 a_1468_5863# a_1380_5960# 0.30831f
C2464 a_9220_15748# a_9308_15704# 0.30831f
C2465 a_17148_18407# ana_div_chain\[4\]_inv_notouch_.I 0.07816f
C2466 ana_div_chain\[2\]_dff_notouch_.CLK a_11012_11528# 0.52028f
C2467 dac_div_chain\[1\]_dff_notouch_.CLK a_14728_14640# 0.20972f
C2468 a_1828_1636# a_1916_1592# 0.30831f
C2469 a_1468_2727# VDD 0.32605f
C2470 a_9220_15748# VDD 0.22827f
C2471 a_9756_17272# VDD 0.34391f
C2472 a_3620_9476# a_3708_9432# 0.30831f
C2473 a_1828_1256# VDD 0.2258f
C2474 a_11460_4772# VDD 0.26719f
C2475 a_6420_18504# VDD 0.24879f
C2476 a_17060_11044# a_16700_11000# 0.08717f
C2477 a_6644_4392# a_6756_3204# 0.02666f
C2478 a_18852_11044# VDD 0.23566f
C2479 a_17708_12135# a_17620_12232# 0.30831f
C2480 a_15356_15704# a_13924_15047# 0.05905f
C2481 a_1828_6340# a_1916_6296# 0.30831f
C2482 a_8524_2727# a_8884_2824# 0.08707f
C2483 a_19388_4728# VDD 0.40424f
C2484 a_21428_9096# VDD 0.22827f
C2485 input1.Z a_20060_1159# 0.04401f
C2486 a_20420_14180# avo[0] 0.47111f
C2487 a_15492_1636# a_15580_1592# 0.30831f
C2488 a_1916_1592# a_1916_1159# 0.05841f
C2489 a_2812_13703# a_3172_13800# 0.08717f
C2490 a_7740_6296# VDD 0.34473f
C2491 a_13588_4392# a_13700_3204# 0.02666f
C2492 dac_div_chain\[0\]_inv_notouch_.ZN a_14280_13811# 0.28223f
C2493 a_11460_6340# avo[2] 0.03114f
C2494 a_13228_10567# VDD 0.3484f
C2495 a_11424_11115# a_12352_11485# 1.16478f
C2496 a_11012_11528# a_11980_11529# 0.22071f
C2497 VDD avo[5] 0.83561f
C2498 a_8884_15368# VDD 0.22894f
C2499 a_19500_2727# a_19412_2824# 0.30831f
C2500 a_19500_4295# VDD 0.38302f
C2501 a_5388_15271# a_5748_15368# 0.08707f
C2502 a_1828_12232# VDD 0.2258f
C2503 a_6644_9096# a_6756_7908# 0.02666f
C2504 a_2364_10567# a_2724_10664# 0.08717f
C2505 a_19748_1636# a_19388_1592# 0.08717f
C2506 a_14036_2824# VDD 0.22897f
C2507 a_21540_6340# VDD 0.22854f
C2508 a_20532_4392# a_20644_3204# 0.02666f
C2509 a_15828_10664# VDD 0.23048f
C2510 a_8524_7431# a_8884_7528# 0.08707f
C2511 a_4156_7864# VDD 0.33493f
C2512 a_1916_6296# a_1916_5863# 0.05841f
C2513 a_15492_6340# a_15580_6296# 0.30831f
C2514 ana_div_chain\[4\]_dff_notouch_.Q a_18940_17272# 0.04558f
C2515 a_13588_9096# a_13700_7908# 0.02666f
C2516 a_1380_16936# a_1380_15748# 0.05841f
C2517 a_15468_10567# a_15380_10664# 0.30831f
C2518 a_6284_12135# a_6644_12232# 0.08674f
C2519 a_15916_5863# VDD 0.34315f
C2520 a_5500_12568# a_5388_12135# 0.02634f
C2521 a_8100_14180# a_7740_14136# 0.08663f
C2522 a_13116_14136# VDD 0.36588f
C2523 a_19500_7431# a_19412_7528# 0.30831f
C2524 a_10228_4392# VDD 0.22854f
C2525 a_17956_7908# VDD 0.23149f
C2526 a_4940_4295# a_5300_4392# 0.08707f
C2527 a_19748_6340# a_19388_6296# 0.08717f
C2528 a_8860_6296# a_8972_5863# 0.02634f
C2529 a_4068_17316# a_4156_17272# 0.30831f
C2530 a_4516_1636# VDD 0.23094f
C2531 a_20532_9096# a_20644_7908# 0.02666f
C2532 a_13876_13639# a_14320_13443# 0.04722f
C2533 a_11908_3204# a_11996_3160# 0.30831f
C2534 a_6308_9476# VDD 0.22854f
C2535 a_3260_11000# VDD 0.33424f
C2536 ana_div_chain\[2\]_dff_notouch_.Q a_12152_12637# 0.04176f
C2537 a_20620_16839# a_20980_16936# 0.0869f
C2538 a_15916_4295# a_15828_4392# 0.30831f
C2539 a_8902_13040# a_9892_12612# 0.19579f
C2540 a_12108_7431# VDD 0.37606f
C2541 a_15398_14516# input2.Z 0.79412f
C2542 a_9408_13800# a_10336_13443# 1.16478f
C2543 a_4156_1159# a_4068_1256# 0.30831f
C2544 a_10652_1592# VDD 0.35822f
C2545 a_16700_6296# a_16812_5863# 0.02634f
C2546 a_6284_13703# VDD 0.34315f
C2547 a_6644_5960# VDD 0.22827f
C2548 a_5748_16936# VDD 0.22827f
C2549 uio_oe[5] uio_oe[4] 0.0541f
C2550 a_13900_9432# VDD 0.35864f
C2551 a_4940_8999# a_5300_9096# 0.08707f
C2552 a_8772_4772# dvo[3] 0.0441f
C2553 a_3172_15748# a_2812_15704# 0.08707f
C2554 a_13924_15047# a_16192_15011# 0.03873f
C2555 a_18740_18504# a_18852_17316# 0.02666f
C2556 a_21964_12135# VDD 0.37888f
C2557 a_11908_7908# a_11996_7864# 0.30831f
C2558 a_5860_12612# a_5948_12568# 0.30831f
C2559 a_3596_18407# a_3508_18504# 0.30831f
C2560 a_15132_1159# a_15492_1256# 0.08717f
C2561 a_4828_1159# VDD 0.36325f
C2562 a_5412_4772# a_5052_4728# 0.08707f
C2563 a_17596_12568# a_17708_12135# 0.02634f
C2564 a_16028_3160# a_15916_2727# 0.02634f
C2565 a_8524_8999# VDD 0.36017f
C2566 a_14596_3204# VDD 0.22854f
C2567 ana_div_chain\[2\]_inv_notouch_.ZN a_12020_9476# 0.10942f
C2568 a_6756_17316# VDD 0.22846f
C2569 input1.Z a_20732_1592# 0.0473f
C2570 a_15916_8999# a_15828_9096# 0.30831f
C2571 a_2724_7528# VDD 0.23014f
C2572 a_1020_16839# VDD 0.33f
C2573 a_15268_17316# a_14908_17272# 0.08674f
C2574 a_5300_15368# a_5412_14180# 0.02666f
C2575 a_9220_15748# a_8860_15704# 0.0869f
C2576 a_1020_5863# a_1380_5960# 0.08717f
C2577 a_21964_16839# VDD 0.36451f
C2578 a_17148_18407# a_17060_18504# 0.30831f
C2579 a_1828_1636# a_1468_1592# 0.08707f
C2580 a_1020_2727# VDD 0.33f
C2581 a_9308_17272# VDD 0.34315f
C2582 a_5500_15704# a_5388_15271# 0.02634f
C2583 a_12108_5863# a_12020_5960# 0.30831f
C2584 a_8772_15748# VDD 0.24899f
C2585 a_12692_15368# a_12580_14180# 0.02666f
C2586 a_1380_1256# VDD 0.2258f
C2587 a_3620_9476# a_3260_9432# 0.08707f
C2588 a_5188_18504# VDD 0.25706f
C2589 a_11012_4772# VDD 0.23391f
C2590 a_16028_7864# a_15916_7431# 0.02634f
C2591 a_5500_4728# a_5388_4295# 0.02634f
C2592 a_16612_11044# a_16700_11000# 0.30831f
C2593 ana_div_chain\[4\]_inv_notouch_.I ana_div_chain\[4\]_inv_notouch_.ZN 0.5034f
C2594 a_18404_11044# VDD 0.23388f
C2595 a_17260_12135# a_17620_12232# 0.08717f
C2596 ana_div_chain\[1\]_dff_notouch_.CLK a_19768_13397# 0.21362f
C2597 a_4852_13800# a_4964_12612# 0.02666f
C2598 a_1828_6340# a_1468_6296# 0.08707f
C2599 a_18940_4728# VDD 0.35234f
C2600 a_8524_2727# a_8436_2824# 0.30831f
C2601 a_20980_9096# VDD 0.22827f
C2602 a_15492_1636# a_15132_1592# 0.08707f
C2603 a_7292_6296# VDD 0.34473f
C2604 dac_div_chain\[0\]_inv_notouch_.ZN a_14320_13443# 0.1384f
C2605 a_2812_13703# a_2724_13800# 0.30831f
C2606 a_12780_10567# VDD 0.33161f
C2607 a_11012_11528# a_12352_11485# 0.08109f
C2608 a_8436_15368# VDD 0.23094f
C2609 a_5388_15271# a_5300_15368# 0.30831f
C2610 a_19052_2727# a_19412_2824# 0.08707f
C2611 a_19052_4295# VDD 0.35643f
C2612 a_1380_12232# VDD 0.2258f
C2613 a_2364_10567# a_2276_10664# 0.30831f
C2614 a_13588_2824# VDD 0.22897f
C2615 a_19300_1636# a_19388_1592# 0.30831f
C2616 a_21092_6340# VDD 0.22854f
C2617 dac_div_chain\[3\]_inv_notouch_.I a_10788_17316# 0.7861f
C2618 a_15380_10664# VDD 0.23048f
C2619 a_8524_7431# a_8436_7528# 0.30831f
C2620 a_3708_7864# VDD 0.37719f
C2621 a_12108_9432# a_12108_8999# 0.05841f
C2622 a_15492_6340# a_15132_6296# 0.08707f
C2623 a_4156_16839# a_4068_16936# 0.30831f
C2624 a_15020_10567# a_15380_10664# 0.08707f
C2625 a_6284_12135# a_6196_12232# 0.30831f
C2626 a_2724_5960# a_2724_4772# 0.05841f
C2627 a_15468_5863# VDD 0.34315f
C2628 a_7652_14180# a_7740_14136# 0.30831f
C2629 a_12668_14136# VDD 0.34315f
C2630 a_19052_7431# a_19412_7528# 0.08707f
C2631 a_9780_4392# VDD 0.22854f
C2632 a_4940_4295# a_4852_4392# 0.30831f
C2633 a_17508_7908# VDD 0.22881f
C2634 a_19300_6340# a_19388_6296# 0.30831f
C2635 a_4068_1636# VDD 0.23871f
C2636 a_4068_17316# a_3708_17272# 0.08707f
C2637 a_11908_3204# a_11548_3160# 0.08707f
C2638 a_1020_17272# a_1020_16839# 0.05841f
C2639 a_9780_5960# a_9668_4772# 0.02666f
C2640 a_5860_9476# VDD 0.22854f
C2641 a_2812_11000# VDD 0.33144f
C2642 ana_div_chain\[2\]_dff_notouch_.Q a_12192_13053# 0.09301f
C2643 a_20620_16839# a_20532_16936# 0.30831f
C2644 a_11660_7431# VDD 0.39825f
C2645 a_15468_4295# a_15828_4392# 0.08707f
C2646 a_5836_13703# VDD 0.34315f
C2647 a_10204_1592# VDD 0.35817f
C2648 a_3708_1159# a_4068_1256# 0.08717f
C2649 a_6196_5960# VDD 0.22827f
C2650 a_5300_16936# VDD 0.22827f
C2651 a_16724_5960# a_16612_4772# 0.02666f
C2652 a_13452_9432# VDD 0.35864f
C2653 a_4940_8999# a_4852_9096# 0.30831f
C2654 a_6644_12232# a_6756_11044# 0.02666f
C2655 a_13924_15047# a_15899_15423# 0.04722f
C2656 a_21876_15368# VDD 0.23499f
C2657 a_2724_15748# a_2812_15704# 0.30831f
C2658 a_21516_12135# VDD 0.34131f
C2659 a_11908_7908# a_11548_7864# 0.08707f
C2660 a_5860_12612# a_5500_12568# 0.08707f
C2661 a_4156_1159# VDD 0.36333f
C2662 a_4964_4772# a_5052_4728# 0.30831f
C2663 a_15132_1159# a_15044_1256# 0.30831f
C2664 a_18292_15368# a_18404_14180# 0.02666f
C2665 a_8076_8999# VDD 0.34315f
C2666 a_6308_17316# VDD 0.22846f
C2667 a_14148_3204# VDD 0.22854f
C2668 VDD avo[1] 1.13142f
C2669 a_15468_8999# a_15828_9096# 0.08707f
C2670 a_2276_7528# VDD 0.22866f
C2671 a_22076_17272# VDD 0.3731f
C2672 a_10228_4392# avo[3] 0.04471f
C2673 a_21516_16839# VDD 0.34324f
C2674 a_14820_17316# a_14908_17272# 0.30831f
C2675 a_8772_15748# a_8860_15704# 0.30831f
C2676 a_16700_18407# a_17060_18504# 0.08663f
C2677 a_1380_1636# a_1468_1592# 0.30831f
C2678 a_8792_10261# dvo[3] 0.54543f
C2679 a_22076_3160# VDD 0.37268f
C2680 a_8902_13040# dac_div_chain\[1\]_inv_notouch_.I 0.76135f
C2681 a_11660_5863# a_12020_5960# 0.08663f
C2682 a_3172_9476# a_3260_9432# 0.30831f
C2683 a_8860_17272# VDD 0.34777f
C2684 a_8188_15704# VDD 0.37312f
C2685 a_3956_18504# VDD 0.27582f
C2686 a_10564_4772# VDD 0.2318f
C2687 a_7204_11044# a_7292_11000# 0.30831f
C2688 ana_div_chain\[4\]_inv_notouch_.I a_16352_16936# 0.03899f
C2689 a_6196_4392# a_6308_3204# 0.02666f
C2690 a_17956_11044# VDD 0.23149f
C2691 a_932_2824# VDD 0.24399f
C2692 input2.Z a_16611_808# 0.22124f
C2693 a_17260_12135# a_17172_12232# 0.30831f
C2694 a_21740_15704# VDD 0.37827f
C2695 a_21709_808# VDD 0.78036f
C2696 a_1380_6340# a_1468_6296# 0.30831f
C2697 a_18492_4728# VDD 0.34923f
C2698 a_8076_2727# a_8436_2824# 0.08707f
C2699 a_20532_9096# VDD 0.24899f
C2700 a_11996_4728# a_12108_4295# 0.02634f
C2701 a_15044_1636# a_15132_1592# 0.30831f
C2702 a_1468_1592# a_1468_1159# 0.05841f
C2703 a_6844_6296# VDD 0.34473f
C2704 a_2364_13703# a_2724_13800# 0.08717f
C2705 a_13140_4392# a_13252_3204# 0.02666f
C2706 dac_div_chain\[0\]_inv_notouch_.ZN a_13876_13639# 0.03298f
C2707 a_11366_10216# VDD 0.95701f
C2708 a_10419_18100# uio_oe[0] 0.04649f
C2709 a_4940_15271# a_5300_15368# 0.08707f
C2710 a_4156_9432# a_4156_8999# 0.05841f
C2711 a_7988_15368# VDD 0.22827f
C2712 a_18604_4295# VDD 0.35143f
C2713 a_19052_2727# a_18964_2824# 0.30831f
C2714 a_932_12232# VDD 0.24399f
C2715 a_6196_9096# a_6308_7908# 0.02666f
C2716 a_19836_4728# a_19948_4295# 0.02634f
C2717 a_13140_2824# VDD 0.22897f
C2718 a_1916_10567# a_2276_10664# 0.08717f
C2719 a_19300_1636# a_18940_1592# 0.08717f
C2720 a_20644_6340# VDD 0.22854f
C2721 a_14932_10664# VDD 0.23048f
C2722 a_8972_7431# dvo[3] 0.04613f
C2723 a_8076_7431# a_8436_7528# 0.08707f
C2724 a_3260_7864# VDD 0.33422f
C2725 a_1468_6296# a_1468_5863# 0.05841f
C2726 a_15044_6340# a_15132_6296# 0.30831f
C2727 a_13140_9096# a_13252_7908# 0.02666f
C2728 a_16724_12232# a_16612_11044# 0.02666f
C2729 a_3708_16839# a_4068_16936# 0.08717f
C2730 a_932_16936# a_932_15748# 0.05841f
C2731 a_15020_10567# a_14932_10664# 0.30831f
C2732 a_5836_12135# a_6196_12232# 0.0869f
C2733 a_5052_12568# a_4940_12135# 0.02634f
C2734 a_15020_5863# VDD 0.34315f
C2735 a_7652_14180# a_7292_14136# 0.08707f
C2736 a_19052_7431# a_18964_7528# 0.30831f
C2737 a_9332_4392# VDD 0.22854f
C2738 a_12220_14136# VDD 0.35806f
C2739 a_17060_7908# VDD 0.22827f
C2740 a_19836_9432# a_19948_8999# 0.02634f
C2741 a_3620_1636# VDD 0.25323f
C2742 a_19300_6340# a_18940_6296# 0.08717f
C2743 a_3620_17316# a_3708_17272# 0.30831f
C2744 a_11460_3204# a_11548_3160# 0.30831f
C2745 a_5412_9476# VDD 0.22854f
C2746 a_2364_11000# VDD 0.32958f
C2747 a_15468_4295# a_15380_4392# 0.30831f
C2748 a_11212_7431# VDD 0.35295f
C2749 a_9756_1592# VDD 0.35817f
C2750 a_3708_1159# a_3620_1256# 0.30831f
C2751 wire12.I dac_div_chain\[1\]_inv_notouch_.I 0.08538f
C2752 a_5388_13703# VDD 0.34317f
C2753 a_5748_5960# VDD 0.22827f
C2754 a_4852_16936# VDD 0.24963f
C2755 a_13004_9432# VDD 0.35867f
C2756 a_13924_15047# a_14892_15055# 0.22071f
C2757 a_21428_15368# VDD 0.22924f
C2758 a_2724_15748# a_2364_15704# 0.08707f
C2759 a_21068_12135# VDD 0.34645f
C2760 a_11460_7908# a_11548_7864# 0.30831f
C2761 a_5412_12612# a_5500_12568# 0.30831f
C2762 a_4964_4772# a_4604_4728# 0.08707f
C2763 a_14684_1159# a_15044_1256# 0.08717f
C2764 a_3708_1159# VDD 0.37202f
C2765 a_17148_12568# a_17260_12135# 0.02634f
C2766 a_15580_3160# a_15468_2727# 0.02634f
C2767 a_7628_8999# VDD 0.34315f
C2768 a_11212_8999# avo[2] 0.05746f
C2769 a_13700_3204# VDD 0.22854f
C2770 a_5860_17316# VDD 0.23034f
C2771 a_15468_8999# a_15380_9096# 0.30831f
C2772 a_1828_7528# VDD 0.2258f
C2773 a_21628_17272# VDD 0.34483f
C2774 a_4852_15368# a_4964_14180# 0.02666f
C2775 dac_div_chain\[1\]_dff_notouch_.CLK VDD 0.71103f
C2776 a_21068_16839# VDD 0.34324f
C2777 a_14820_17316# a_14460_17272# 0.08674f
C2778 a_16700_18407# a_16612_18504# 0.30831f
C2779 a_1380_1636# a_1020_1592# 0.08707f
C2780 dac_div_chain\[2\]_load_slew15.Z dvo[2] 0.03636f
C2781 a_21628_3160# VDD 0.34473f
C2782 a_12020_15368# a_12132_14180# 0.02666f
C2783 a_3172_9476# a_2812_9432# 0.08707f
C2784 a_11660_5863# a_11572_5960# 0.30831f
C2785 a_5052_15704# a_4940_15271# 0.02634f
C2786 a_15268_17316# VDD 0.2312f
C2787 a_7740_15704# VDD 0.34473f
C2788 a_3508_18504# VDD 0.25728f
C2789 a_10116_4772# VDD 0.23059f
C2790 a_15580_7864# a_15468_7431# 0.02634f
C2791 a_10204_1592# avo[3] 0.06338f
C2792 a_5052_4728# a_4940_4295# 0.02634f
C2793 a_7204_11044# a_6844_11000# 0.08663f
C2794 a_17508_11044# VDD 0.22881f
C2795 a_21964_2727# VDD 0.36442f
C2796 a_16812_12135# a_17172_12232# 0.08717f
C2797 a_21292_15704# VDD 0.35859f
C2798 a_21085_808# VDD 0.57781f
C2799 a_8076_2727# a_7988_2824# 0.30831f
C2800 a_18044_4728# VDD 0.34714f
C2801 a_1380_6340# a_1020_6296# 0.08707f
C2802 a_19860_9096# VDD 0.23913f
C2803 a_15044_1636# a_14684_1592# 0.08707f
C2804 a_2364_13703# a_2276_13800# 0.30831f
C2805 a_6396_6296# VDD 0.34473f
C2806 a_10764_10567# VDD 0.36546f
C2807 VDD uio_oe[2] 0.32552f
C2808 a_4940_15271# a_4852_15368# 0.30831f
C2809 a_7540_15368# VDD 0.22827f
C2810 a_18156_4295# VDD 0.34917f
C2811 a_18604_2727# a_18964_2824# 0.08707f
C2812 a_7764_11911# VDD 2.23244f
C2813 a_18852_1636# a_18940_1592# 0.30831f
C2814 a_1916_10567# a_1828_10664# 0.30831f
C2815 a_12692_2824# VDD 0.24969f
C2816 a_20196_6340# VDD 0.23094f
C2817 a_19860_4392# a_19748_3204# 0.02666f
C2818 a_14484_10664# VDD 0.23048f
C2819 a_8076_7431# a_7988_7528# 0.30831f
C2820 a_2812_7864# VDD 0.33144f
C2821 a_10564_4772# avo[3] 0.03114f
C2822 a_15044_6340# a_14684_6296# 0.08707f
C2823 a_8100_3204# a_8188_3160# 0.30831f
C2824 a_3708_16839# a_3620_16936# 0.30831f
C2825 a_2276_5960# a_2276_4772# 0.05841f
C2826 a_14572_10567# a_14932_10664# 0.08707f
C2827 a_5836_12135# a_5748_12232# 0.30831f
C2828 a_14572_5863# VDD 0.34315f
C2829 dac_div_chain\[1\]_inv_notouch_.ZN VDD 0.61572f
C2830 a_7204_14180# a_7292_14136# 0.30831f
C2831 a_8884_4392# VDD 0.22854f
C2832 a_18604_7431# a_18964_7528# 0.08707f
C2833 a_11772_14136# VDD 0.37268f
C2834 a_4156_4295# a_4068_4392# 0.30831f
C2835 a_16612_7908# VDD 0.24899f
C2836 a_18852_6340# a_18940_6296# 0.30831f
C2837 a_3172_1636# VDD 0.23225f
C2838 a_3620_17316# a_3260_17272# 0.08707f
C2839 a_19860_9096# a_19748_7908# 0.02666f
C2840 a_11460_3204# a_11100_3160# 0.08707f
C2841 a_4964_9476# VDD 0.22854f
C2842 a_9332_5960# a_9220_4772# 0.02666f
C2843 a_1916_11000# VDD 0.32626f
C2844 a_10764_7431# VDD 0.351f
C2845 a_8100_7908# a_8188_7864# 0.30831f
C2846 a_15020_4295# a_15380_4392# 0.08707f
C2847 a_9308_1592# VDD 0.35817f
C2848 wire12.I a_8902_13040# 0.08791f
C2849 a_3260_1159# a_3620_1256# 0.08717f
C2850 a_4940_13703# VDD 0.34876f
C2851 a_5300_5960# VDD 0.22827f
C2852 a_4068_16936# VDD 0.24448f
C2853 a_12556_9432# VDD 0.35803f
C2854 a_19748_14180# a_19836_14136# 0.30831f
C2855 a_6868_18504# a_6756_17316# 0.02666f
C2856 a_4156_8999# a_4068_9096# 0.30831f
C2857 a_13924_15047# a_15264_15011# 0.08109f
C2858 a_20980_15368# VDD 0.22971f
C2859 a_6196_12232# a_6308_11044# 0.02666f
C2860 a_2276_15748# a_2364_15704# 0.30831f
C2861 a_20620_12135# VDD 0.35815f
C2862 a_11460_7908# a_11100_7864# 0.08707f
C2863 a_4516_4772# a_4604_4728# 0.30831f
C2864 a_3260_1159# VDD 0.33424f
C2865 a_2588_18407# a_2500_18504# 0.30831f
C2866 a_5412_12612# a_5052_12568# 0.08707f
C2867 a_14684_1159# a_14596_1256# 0.30831f
C2868 a_17844_15368# a_17956_14180# 0.02666f
C2869 a_7180_8999# VDD 0.34315f
C2870 a_5412_17316# VDD 0.23082f
C2871 a_13252_3204# VDD 0.22854f
C2872 a_1380_7528# VDD 0.2258f
C2873 a_15020_8999# a_15380_9096# 0.08707f
C2874 a_13028_14180# VDD 0.23024f
C2875 a_21180_17272# VDD 0.34483f
C2876 a_20620_16839# VDD 0.34789f
C2877 a_14372_17316# a_14460_17272# 0.30831f
C2878 a_16252_18407# a_16612_18504# 0.08674f
C2879 dac_div_chain\[4\]_inv_notouch_.I a_13140_16936# 0.05275f
C2880 dac_div_chain\[3\]_inv_notouch_.I a_10764_15271# 0.05155f
C2881 a_21180_3160# VDD 0.34473f
C2882 input2.Z a_16724_5960# 0.03114f
C2883 a_2724_9476# a_2812_9432# 0.30831f
C2884 a_11212_5863# a_11572_5960# 0.08707f
C2885 a_14820_17316# VDD 0.23082f
C2886 a_7292_15704# VDD 0.34473f
C2887 a_9668_4772# VDD 0.22831f
C2888 a_2500_18504# VDD 0.2367f
C2889 a_6756_11044# a_6844_11000# 0.30831f
C2890 a_5748_4392# a_5860_3204# 0.02666f
C2891 a_17060_11044# VDD 0.22827f
C2892 a_21516_2727# VDD 0.34315f
C2893 a_932_5960# a_932_4772# 0.05841f
C2894 a_19972_1256# VDD 0.24979f
C2895 a_20844_15704# VDD 0.35819f
C2896 VDD avo[2] 2.91157f
C2897 a_4068_13800# a_4068_12612# 0.05841f
C2898 a_7628_2727# a_7988_2824# 0.08707f
C2899 a_17596_4728# VDD 0.34462f
C2900 a_19412_9096# VDD 0.28341f
C2901 a_11548_4728# a_11660_4295# 0.02634f
C2902 a_15916_11000# a_15916_10567# 0.05841f
C2903 a_14596_1636# a_14684_1592# 0.30831f
C2904 a_1020_1592# a_1020_1159# 0.05841f
C2905 a_1916_13703# a_2276_13800# 0.08717f
C2906 a_12692_4392# a_12804_3204# 0.02666f
C2907 a_5948_6296# VDD 0.34473f
C2908 a_10316_10567# VDD 0.34949f
C2909 a_17565_808# dac_vco_in 0.47426f
C2910 a_8902_11472# dvo[2] 0.04429f
C2911 a_3708_9432# a_3708_8999# 0.05841f
C2912 a_7092_15368# VDD 0.22827f
C2913 a_18604_2727# a_18516_2824# 0.30831f
C2914 a_17708_4295# VDD 0.3475f
C2915 a_7180_12135# VDD 0.35547f
C2916 a_19388_4728# a_19500_4295# 0.02634f
C2917 a_5748_9096# a_5860_7908# 0.02666f
C2918 a_18852_1636# a_18492_1592# 0.08717f
C2919 a_12020_2824# VDD 0.24175f
C2920 a_1468_10567# a_1828_10664# 0.08717f
C2921 a_19748_6340# VDD 0.2357f
C2922 a_14036_10664# VDD 0.23048f
C2923 a_7628_7431# a_7988_7528# 0.08707f
C2924 a_11100_9432# a_11212_8999# 0.02634f
C2925 a_2364_7864# VDD 0.32958f
C2926 a_14596_6340# a_14684_6296# 0.30831f
C2927 a_1020_6296# a_1020_5863# 0.05841f
C2928 a_12692_9096# a_12804_7908# 0.02666f
C2929 a_3260_16839# a_3620_16936# 0.08717f
C2930 a_8100_3204# a_7740_3160# 0.08663f
C2931 a_14572_10567# a_14484_10664# 0.30831f
C2932 a_5388_12135# a_5748_12232# 0.0869f
C2933 a_14124_5863# VDD 0.34315f
C2934 a_12536_13097# VDD 0.18894f
C2935 a_7204_14180# a_6844_14136# 0.08707f
C2936 a_8436_4392# VDD 0.23094f
C2937 a_18604_7431# a_18516_7528# 0.30831f
C2938 a_11324_14136# VDD 0.36879f
C2939 a_19388_9432# a_19500_8999# 0.02634f
C2940 a_3708_4295# a_4068_4392# 0.08717f
C2941 a_16028_7864# VDD 0.37312f
C2942 a_2724_1636# VDD 0.23014f
C2943 a_18852_6340# a_18492_6296# 0.08717f
C2944 a_3172_17316# a_3260_17272# 0.30831f
C2945 a_11012_3204# a_11100_3160# 0.30831f
C2946 a_4516_9476# VDD 0.23094f
C2947 ana_div_chain\[2\]_dff_notouch_.Q wire20.I 0.10586f
C2948 a_1468_11000# VDD 0.32605f
C2949 dac_div_chain\[2\]_load_slew11.Z VDD 0.777f
C2950 a_19948_16839# a_19860_16936# 0.30831f
C2951 a_15020_4295# a_14932_4392# 0.30831f
C2952 a_8100_7908# a_7740_7864# 0.08663f
C2953 a_10316_7431# VDD 0.34802f
C2954 a_3260_1159# a_3172_1256# 0.30831f
C2955 a_8860_1592# VDD 0.36279f
C2956 a_4156_13703# VDD 0.35632f
C2957 a_8188_3160# a_8076_2727# 0.02634f
C2958 a_4852_5960# VDD 0.24963f
C2959 a_3620_16936# VDD 0.25323f
C2960 a_12108_9432# VDD 0.32943f
C2961 a_19748_14180# a_19388_14136# 0.08717f
C2962 a_3708_8999# a_4068_9096# 0.08717f
C2963 a_20532_15368# VDD 0.25127f
C2964 a_2276_15748# a_1916_15704# 0.08707f
C2965 a_2140_18407# a_2500_18504# 0.08674f
C2966 a_19948_12135# VDD 0.3555f
C2967 a_11012_7908# a_11100_7864# 0.30831f
C2968 a_2812_1159# VDD 0.33144f
C2969 a_4516_4772# a_4156_4728# 0.08707f
C2970 a_4964_12612# a_5052_12568# 0.30831f
C2971 a_14236_1159# a_14596_1256# 0.08717f
C2972 a_15132_3160# a_15020_2727# 0.02634f
C2973 a_16700_12568# a_16812_12135# 0.02634f
C2974 a_6732_8999# VDD 0.34315f
C2975 a_12804_3204# VDD 0.22854f
C2976 a_4964_17316# VDD 0.23087f
C2977 a_15020_8999# a_14932_9096# 0.30831f
C2978 a_20732_17272# VDD 0.34485f
C2979 a_12580_14180# VDD 0.22827f
C2980 a_14372_17316# a_14012_17272# 0.0869f
C2981 a_19948_16839# VDD 0.37427f
C2982 a_8188_7864# a_8076_7431# 0.02634f
C2983 a_16252_18407# a_16164_18504# 0.30831f
C2984 input2.Z dvo[1] 0.06407f
C2985 a_20732_3160# VDD 0.34474f
C2986 a_2724_9476# a_2364_9432# 0.08707f
C2987 a_11572_15368# a_11684_14180# 0.02666f
C2988 a_11212_5863# a_11124_5960# 0.30831f
C2989 a_6844_15704# VDD 0.34473f
C2990 a_2052_18504# VDD 0.25615f
C2991 a_14372_17316# VDD 0.23082f
C2992 a_9220_4772# VDD 0.22827f
C2993 a_15132_7864# a_15020_7431# 0.02634f
C2994 a_6756_11044# a_6396_11000# 0.08674f
C2995 a_16612_11044# VDD 0.24963f
C2996 a_21068_2727# VDD 0.34315f
C2997 a_15468_16839# dvo[0] 0.0357f
C2998 a_19188_1256# VDD 0.25814f
C2999 a_20396_15704# VDD 0.35797f
C3000 a_7628_2727# a_7540_2824# 0.30831f
C3001 a_17148_4728# VDD 0.34315f
C3002 a_21988_4772# a_22076_4728# 0.30831f
C3003 a_18964_9096# VDD 0.23661f
C3004 input2.Z a_16612_3204# 0.05125f
C3005 a_14596_1636# a_14236_1592# 0.08707f
C3006 a_1916_13703# a_1828_13800# 0.30831f
C3007 a_5500_6296# VDD 0.34475f
C3008 a_9868_10567# VDD 0.34513f
C3009 a_16941_808# dac_vco_in 0.09747f
C3010 a_16612_17316# a_15940_16615# 0.06435f
C3011 a_8008_11504# dvo[2] 0.51931f
C3012 a_4156_15271# a_4068_15368# 0.30831f
C3013 a_6644_15368# VDD 0.22827f
C3014 a_17260_4295# VDD 0.34473f
C3015 a_18156_2727# a_18516_2824# 0.08707f
C3016 a_6732_12135# VDD 0.34315f
C3017 a_18404_1636# a_18492_1592# 0.30831f
C3018 a_11572_2824# VDD 0.29206f
C3019 a_1468_10567# a_1380_10664# 0.30831f
C3020 ana_div_chain\[4\]_dff_notouch_.CLK avo[4] 0.06374f
C3021 a_19300_6340# VDD 0.28063f
C3022 a_19412_4392# a_19300_3204# 0.02666f
C3023 a_13588_10664# VDD 0.23048f
C3024 a_7628_7431# a_7540_7528# 0.30831f
C3025 a_21988_9476# a_22076_9432# 0.30831f
C3026 a_1916_7864# VDD 0.32626f
C3027 a_14596_6340# a_14236_6296# 0.08707f
C3028 a_3260_16839# a_3172_16936# 0.30831f
C3029 a_7652_3204# a_7740_3160# 0.30831f
C3030 a_8860_9432# dvo[3] 0.05786f
C3031 a_14124_10567# a_14484_10664# 0.08707f
C3032 a_1828_5960# a_1828_4772# 0.05841f
C3033 a_5388_12135# a_5300_12232# 0.30831f
C3034 a_13676_5863# VDD 0.34315f
C3035 a_4156_12568# a_4156_12135# 0.05841f
C3036 a_12640_12932# VDD 0.4032f
C3037 a_6756_14180# a_6844_14136# 0.30831f
C3038 a_18156_7431# a_18516_7528# 0.08707f
C3039 a_7988_4392# VDD 0.22827f
C3040 avo[2] avo[3] 0.6236f
C3041 a_15580_7864# VDD 0.34473f
C3042 a_3708_4295# a_3620_4392# 0.30831f
C3043 dvo[2] dvo[3] 0.31497f
C3044 a_18404_6340# a_18492_6296# 0.30831f
C3045 a_2276_1636# VDD 0.22866f
C3046 a_3172_17316# a_2812_17272# 0.08707f
C3047 a_19412_9096# a_19300_7908# 0.02666f
C3048 a_11012_3204# a_10652_3160# 0.08707f
C3049 a_8884_5960# a_8772_4772# 0.02666f
C3050 a_4068_9476# VDD 0.23871f
C3051 dac_div_chain\[1\]_dff_notouch_.CLK a_13876_13639# 0.03492f
C3052 a_10316_10567# avo[3] 0.07895f
C3053 a_1020_11000# VDD 0.33f
C3054 a_7652_12612# VDD 0.22938f
C3055 a_19500_16839# a_19860_16936# 0.08674f
C3056 a_14572_4295# a_14932_4392# 0.08707f
C3057 a_7652_7908# a_7740_7864# 0.30831f
C3058 a_3139_18100# uio_oe[5] 0.04649f
C3059 a_9868_7431# VDD 0.34671f
C3060 wire12.I a_10032_11875# 0.27586f
C3061 a_2812_1159# a_3172_1256# 0.08717f
C3062 a_15940_1636# VDD 0.23473f
C3063 a_3708_13703# VDD 0.37719f
C3064 a_7292_11000# a_7180_10567# 0.02634f
C3065 a_4068_5960# VDD 0.24448f
C3066 a_11100_9432# VDD 0.35859f
C3067 a_3172_16936# VDD 0.23225f
C3068 a_19300_14180# a_19388_14136# 0.30831f
C3069 a_6420_18504# a_6308_17316# 0.02666f
C3070 a_3708_8999# a_3620_9096# 0.30831f
C3071 a_11796_16577# dac_div_chain\[4\]_inv_notouch_.I 0.21382f
C3072 a_5748_12232# a_5860_11044# 0.02666f
C3073 a_1828_15748# a_1916_15704# 0.30831f
C3074 a_19500_12135# VDD 0.38872f
C3075 a_2140_18407# a_2052_18504# 0.30831f
C3076 a_11012_7908# a_10652_7864# 0.08707f
C3077 a_14236_1159# a_14148_1256# 0.30831f
C3078 a_4964_12612# a_4604_12568# 0.08707f
C3079 a_4068_4772# a_4156_4728# 0.30831f
C3080 a_2364_1159# VDD 0.32958f
C3081 a_17396_15368# a_17508_14180# 0.02666f
C3082 a_6284_8999# VDD 0.34315f
C3083 a_4516_17316# VDD 0.23079f
C3084 a_12356_3204# VDD 0.23094f
C3085 a_15828_2824# a_15940_1636# 0.02666f
C3086 a_14572_8999# a_14932_9096# 0.08707f
C3087 input1.Z a_20532_5960# 0.0441f
C3088 a_20284_17272# VDD 0.3599f
C3089 a_12132_14180# VDD 0.23174f
C3090 a_4068_15368# a_4068_14180# 0.05841f
C3091 a_13924_17316# a_14012_17272# 0.30831f
C3092 a_19500_16839# VDD 0.38577f
C3093 a_15398_14516# dvo[1] 0.0316f
C3094 a_20284_3160# VDD 0.35948f
C3095 a_932_6340# VDD 0.24399f
C3096 a_10764_5863# a_11124_5960# 0.08707f
C3097 a_13924_17316# VDD 0.23082f
C3098 a_2276_9476# a_2364_9432# 0.30831f
C3099 a_6396_15704# VDD 0.34473f
C3100 a_4156_15704# a_4156_15271# 0.05841f
C3101 a_10316_7431# avo[3] 0.05714f
C3102 a_21852_18407# VDD 0.3606f
C3103 a_8772_4772# VDD 0.24899f
C3104 input1.Z a_20644_3204# 0.05679f
C3105 a_8884_2824# dvo[3] 0.05946f
C3106 a_4156_4728# a_4156_4295# 0.05841f
C3107 a_6308_11044# a_6396_11000# 0.30831f
C3108 a_15828_7528# a_15940_6340# 0.02666f
C3109 a_5300_4392# a_5412_3204# 0.02666f
C3110 a_15916_11000# VDD 0.34743f
C3111 a_20620_2727# VDD 0.34779f
C3112 a_15020_16839# dvo[0] 0.02615f
C3113 a_21964_5863# a_21876_5960# 0.30831f
C3114 a_18740_1256# VDD 0.23235f
C3115 a_19948_15704# VDD 0.35971f
C3116 a_3620_13800# a_3620_12612# 0.05841f
C3117 a_16700_4728# VDD 0.34777f
C3118 a_7180_2727# a_7540_2824# 0.08707f
C3119 a_18516_9096# VDD 0.23398f
C3120 a_21988_4772# a_21628_4728# 0.08663f
C3121 a_11100_4728# a_11212_4295# 0.02634f
C3122 a_15468_11000# a_15468_10567# 0.05841f
C3123 a_14148_1636# a_14236_1592# 0.30831f
C3124 a_1468_13703# a_1828_13800# 0.08717f
C3125 a_5052_6296# VDD 0.34477f
C3126 a_9420_10567# VDD 0.35002f
C3127 dac_div_chain\[1\]_dff_notouch_.CLK dac_div_chain\[0\]_inv_notouch_.ZN 0.39758f
C3128 ana_div_chain\[2\]_dff_notouch_.CLK ana_div_chain\[2\]_inv_notouch_.I 0.08312f
C3129 a_3260_9432# a_3260_8999# 0.05841f
C3130 a_6196_15368# VDD 0.22827f
C3131 a_3708_15271# a_4068_15368# 0.08717f
C3132 a_18156_2727# a_18068_2824# 0.30831f
C3133 a_16812_4295# VDD 0.34473f
C3134 a_6284_12135# VDD 0.34315f
C3135 a_5300_9096# a_5412_7908# 0.02666f
C3136 a_18940_4728# a_19052_4295# 0.02634f
C3137 a_18404_1636# a_18044_1592# 0.08717f
C3138 a_1020_10567# a_1380_10664# 0.08717f
C3139 a_11124_2824# VDD 0.23619f
C3140 a_18852_6340# VDD 0.2354f
C3141 a_13140_10664# VDD 0.23048f
C3142 a_7180_7431# a_7540_7528# 0.08707f
C3143 a_21988_9476# a_21628_9432# 0.08663f
C3144 a_10652_9432# a_10764_8999# 0.02634f
C3145 a_1468_7864# VDD 0.32605f
C3146 a_14148_6340# a_14236_6296# 0.30831f
C3147 ana_div_chain\[0\]_dff_notouch_.Q VDD 0.46993f
C3148 a_7652_3204# a_7292_3160# 0.08707f
C3149 a_2812_16839# a_3172_16936# 0.08717f
C3150 a_14124_10567# a_14036_10664# 0.30831f
C3151 a_4940_12135# a_5300_12232# 0.0869f
C3152 a_13228_5863# VDD 0.34317f
C3153 a_12152_12637# VDD 1.1201f
C3154 a_6756_14180# a_6396_14136# 0.08707f
C3155 a_7540_4392# VDD 0.22827f
C3156 a_18156_7431# a_18068_7528# 0.30831f
C3157 a_18940_9432# a_19052_8999# 0.02634f
C3158 a_15132_7864# VDD 0.34473f
C3159 a_3260_4295# a_3620_4392# 0.08717f
C3160 a_15828_12612# a_15916_12568# 0.30831f
C3161 a_2724_17316# a_2812_17272# 0.30831f
C3162 a_18404_6340# a_18044_6296# 0.08717f
C3163 a_1828_1636# VDD 0.2258f
C3164 a_11424_11115# ana_div_chain\[2\]_inv_notouch_.ZN 0.24934f
C3165 a_10564_3204# a_10652_3160# 0.30831f
C3166 ana_div_chain\[3\]_inv_notouch_.I a_15940_16615# 0.06219f
C3167 a_3620_9476# VDD 0.25323f
C3168 a_7204_11044# VDD 0.23031f
C3169 a_7204_12612# VDD 0.22854f
C3170 ana_div_chain\[3\]_inv_notouch_.I a_17396_15368# 0.05164f
C3171 a_22076_17272# a_21964_16839# 0.02634f
C3172 a_19500_16839# a_19412_16936# 0.30831f
C3173 uio_oe[1] uio_oe[0] 0.079f
C3174 a_21652_13800# a_20896_13053# 0.0368f
C3175 wire12.I a_9739_12287# 0.04415f
C3176 a_14572_4295# a_14484_4392# 0.30831f
C3177 a_9420_7431# VDD 0.34473f
C3178 a_7652_7908# a_7292_7864# 0.08707f
C3179 a_2812_1159# a_2724_1256# 0.30831f
C3180 a_15492_1636# VDD 0.22854f
C3181 a_3260_13703# VDD 0.33424f
C3182 a_7740_3160# a_7628_2727# 0.02634f
C3183 a_2724_16936# VDD 0.23014f
C3184 a_3620_5960# VDD 0.25323f
C3185 a_10652_9432# VDD 0.34863f
C3186 dac_div_chain\[3\]_inv_notouch_.I a_10764_16839# 0.07367f
C3187 a_19300_14180# a_18940_14136# 0.08717f
C3188 a_3260_8999# a_3620_9096# 0.08717f
C3189 a_19636_15368# VDD 0.24527f
C3190 a_1828_15748# a_1468_15704# 0.08707f
C3191 a_19052_12135# VDD 0.3683f
C3192 a_4516_12612# a_4604_12568# 0.30831f
C3193 a_10564_7908# a_10652_7864# 0.30831f
C3194 a_1916_1159# VDD 0.32626f
C3195 a_4068_4772# a_3708_4728# 0.08707f
C3196 a_13788_1159# a_14148_1256# 0.08717f
C3197 a_14684_3160# a_14572_2727# 0.02634f
C3198 a_5836_8999# VDD 0.34315f
C3199 input1.Z avo[0] 0.04244f
C3200 a_4068_17316# VDD 0.24164f
C3201 a_11908_3204# VDD 0.23801f
C3202 a_14572_8999# a_14484_9096# 0.30831f
C3203 a_19836_17272# VDD 0.3479f
C3204 a_11684_14180# VDD 0.27032f
C3205 a_13924_17316# a_13564_17272# 0.0869f
C3206 a_18208_16579# VDD 0.73111f
C3207 VDD uio_oe[5] 0.34525f
C3208 a_15580_18407# a_15492_18504# 0.30831f
C3209 a_7740_7864# a_7628_7431# 0.02634f
C3210 a_1020_2727# a_932_2824# 0.30831f
C3211 a_19836_3160# VDD 0.34748f
C3212 a_21876_7528# VDD 0.23402f
C3213 a_13476_17316# VDD 0.23082f
C3214 a_10764_5863# a_10676_5960# 0.30831f
C3215 a_11124_15368# a_11236_14180# 0.02666f
C3216 a_2276_9476# a_1916_9432# 0.08707f
C3217 a_21404_18407# VDD 0.3407f
C3218 ana_div_chain\[3\]_inv_notouch_.I a_16700_15704# 0.06477f
C3219 a_5948_15704# VDD 0.34473f
C3220 a_14684_7864# a_14572_7431# 0.02634f
C3221 ana_div_chain\[4\]_inv_notouch_.I a_17620_15748# 0.05989f
C3222 a_8188_4728# VDD 0.37312f
C3223 a_6308_11044# a_5948_11000# 0.08674f
C3224 a_15380_16936# a_15268_15748# 0.02666f
C3225 a_15468_11000# VDD 0.32605f
C3226 a_19948_2727# VDD 0.37418f
C3227 a_21516_5863# a_21876_5960# 0.0869f
C3228 a_18292_1256# VDD 0.15071f
C3229 a_19500_15704# VDD 0.39818f
C3230 a_7180_2727# a_7092_2824# 0.30831f
C3231 a_21988_4772# VDD 0.23471f
C3232 a_1020_7431# a_932_7528# 0.30831f
C3233 a_21540_4772# a_21628_4728# 0.30831f
C3234 a_18068_9096# VDD 0.23212f
C3235 a_14148_1636# a_13788_1592# 0.08707f
C3236 a_1468_13703# a_1380_13800# 0.30831f
C3237 a_4604_6296# VDD 0.35949f
C3238 a_12020_4392# a_11908_3204# 0.02666f
C3239 a_8792_10261# VDD 0.46244f
C3240 dac_div_chain\[1\]_dff_notouch_.CLK a_13116_14136# 0.03476f
C3241 a_5748_15368# VDD 0.22827f
C3242 a_3708_15271# a_3620_15368# 0.30831f
C3243 a_16364_4295# VDD 0.35942f
C3244 a_17708_2727# a_18068_2824# 0.08707f
C3245 a_5836_12135# VDD 0.34315f
C3246 a_1020_10567# a_932_10664# 0.30831f
C3247 a_10676_2824# VDD 0.22869f
C3248 a_17956_1636# a_18044_1592# 0.30831f
C3249 a_18964_4392# a_18852_3204# 0.02666f
C3250 a_18404_6340# VDD 0.23318f
C3251 a_12692_10664# VDD 0.25183f
C3252 a_7180_7431# a_7092_7528# 0.30831f
C3253 a_1020_7864# VDD 0.33f
C3254 a_21540_9476# a_21628_9432# 0.30831f
C3255 a_14148_6340# a_13788_6296# 0.08707f
C3256 a_20662_13352# VDD 0.81467f
C3257 a_12020_9096# a_11908_7908# 0.02666f
C3258 a_7204_3204# a_7292_3160# 0.30831f
C3259 a_2812_16839# a_2724_16936# 0.30831f
C3260 a_13676_10567# a_14036_10664# 0.08707f
C3261 a_1380_5960# a_1380_4772# 0.05841f
C3262 a_3708_12568# a_3708_12135# 0.05841f
C3263 a_4940_12135# a_4852_12232# 0.30831f
C3264 a_12780_5863# VDD 0.3478f
C3265 a_12192_13053# VDD 2.24631f
C3266 a_6308_14180# a_6396_14136# 0.30831f
C3267 a_7092_4392# VDD 0.22827f
C3268 a_17708_7431# a_18068_7528# 0.08707f
C3269 a_14684_7864# VDD 0.34473f
C3270 a_3260_4295# a_3172_4392# 0.30831f
C3271 a_17956_6340# a_18044_6296# 0.30831f
C3272 a_1380_1636# VDD 0.2258f
C3273 a_2724_17316# a_2364_17272# 0.08707f
C3274 a_18964_9096# a_18852_7908# 0.02666f
C3275 a_11012_11528# ana_div_chain\[2\]_inv_notouch_.ZN 0.15608f
C3276 a_10564_3204# a_10204_3160# 0.08707f
C3277 a_3172_9476# VDD 0.23225f
C3278 a_3139_18100# a_3172_17316# 0.02559f
C3279 a_6756_11044# VDD 0.22854f
C3280 a_6756_12612# VDD 0.22854f
C3281 ana_div_chain\[4\]_dff_notouch_.CLK dvo[0] 0.10019f
C3282 a_14124_4295# a_14484_4392# 0.08707f
C3283 wire12.I a_8732_11919# 0.0467f
C3284 a_8972_7431# VDD 0.34473f
C3285 a_7204_7908# a_7292_7864# 0.30831f
C3286 a_15044_1636# VDD 0.22854f
C3287 a_2364_1159# a_2724_1256# 0.08717f
C3288 a_2812_13703# VDD 0.33144f
C3289 a_6844_11000# a_6732_10567# 0.02634f
C3290 a_2276_16936# VDD 0.22866f
C3291 a_3172_5960# VDD 0.23225f
C3292 a_10204_9432# VDD 0.3462f
C3293 a_18852_14180# a_18940_14136# 0.30831f
C3294 a_3260_8999# a_3172_9096# 0.30831f
C3295 a_11256_16533# a_11796_16577# 0.26008f
C3296 a_5300_12232# a_5412_11044# 0.02666f
C3297 a_19188_15368# VDD 0.26017f
C3298 a_1380_15748# a_1468_15704# 0.30831f
C3299 a_10564_7908# a_10204_7864# 0.08707f
C3300 a_18604_12135# VDD 0.35834f
C3301 a_4516_12612# a_4156_12568# 0.08707f
C3302 a_13788_1159# a_13700_1256# 0.30831f
C3303 a_1468_1159# VDD 0.32605f
C3304 a_3620_4772# a_3708_4728# 0.30831f
C3305 a_5388_8999# VDD 0.34317f
C3306 a_3620_17316# VDD 0.25713f
C3307 a_15380_2824# a_15492_1636# 0.02666f
C3308 a_11460_3204# VDD 0.26719f
C3309 a_14124_8999# a_14484_9096# 0.08707f
C3310 a_19388_17272# VDD 0.4052f
C3311 a_17915_16991# VDD 0.38825f
C3312 a_3620_15368# a_3620_14180# 0.05841f
C3313 a_11236_14180# VDD 0.22272f
C3314 a_13476_17316# a_13564_17272# 0.30831f
C3315 a_15132_18407# a_15492_18504# 0.08717f
C3316 a_9739_12287# a_10032_11875# 0.49886f
C3317 a_19388_3160# VDD 0.40424f
C3318 a_21428_7528# VDD 0.22827f
C3319 a_1828_9476# a_1916_9432# 0.30831f
C3320 a_5500_15704# VDD 0.34475f
C3321 a_13028_17316# VDD 0.14303f
C3322 a_10316_5863# a_10676_5960# 0.08707f
C3323 a_3708_15704# a_3708_15271# 0.05841f
C3324 a_20956_18407# VDD 0.34072f
C3325 a_7740_4728# VDD 0.34473f
C3326 a_3708_4728# a_3708_4295# 0.05841f
C3327 a_11460_4772# avo[2] 0.02784f
C3328 a_5860_11044# a_5948_11000# 0.30831f
C3329 a_15380_7528# a_15492_6340# 0.02666f
C3330 a_4852_4392# a_4964_3204# 0.02666f
C3331 a_19500_2727# VDD 0.38302f
C3332 a_15020_11000# VDD 0.3264f
C3333 a_21516_5863# a_21428_5960# 0.30831f
C3334 a_19052_15704# VDD 0.37036f
C3335 a_3172_13800# a_3172_12612# 0.05841f
C3336 a_21540_4772# VDD 0.22854f
C3337 a_6732_2727# a_7092_2824# 0.08707f
C3338 a_17620_9096# VDD 0.22999f
C3339 a_10652_4728# a_10764_4295# 0.02634f
C3340 a_21540_4772# a_21180_4728# 0.0869f
C3341 a_13700_1636# a_13788_1592# 0.30831f
C3342 a_15020_11000# a_15020_10567# 0.05841f
C3343 a_1020_13703# a_1380_13800# 0.08717f
C3344 a_4156_6296# VDD 0.33493f
C3345 a_8076_10567# VDD 0.35953f
C3346 a_13028_14180# a_13116_14136# 0.30831f
C3347 a_5300_15368# VDD 0.22827f
C3348 a_2812_9432# a_2812_8999# 0.05841f
C3349 a_3260_15271# a_3620_15368# 0.08717f
C3350 a_17708_2727# a_17620_2824# 0.30831f
C3351 a_15916_4295# VDD 0.34315f
C3352 a_5388_12135# VDD 0.34317f
C3353 a_4852_9096# a_4964_7908# 0.02666f
C3354 a_18492_4728# a_18604_4295# 0.02634f
C3355 a_17956_1636# a_17596_1592# 0.08717f
C3356 a_10228_2824# VDD 0.22869f
C3357 a_17956_6340# VDD 0.23149f
C3358 a_10676_10664# VDD 0.23398f
C3359 a_6732_7431# a_7092_7528# 0.08707f
C3360 a_10204_9432# a_10316_8999# 0.02634f
C3361 a_8100_7908# VDD 0.23473f
C3362 a_21540_9476# a_21180_9432# 0.0869f
C3363 a_13700_6340# a_13788_6296# 0.30831f
C3364 a_2364_16839# a_2724_16936# 0.08717f
C3365 a_19768_13397# VDD 0.56749f
C3366 a_7204_3204# a_6844_3160# 0.08707f
C3367 a_13676_10567# a_13588_10664# 0.30831f
C3368 a_12108_5863# VDD 0.37606f
C3369 ana_div_chain\[1\]_dff_notouch_.CLK a_14432_11875# 0.52619f
C3370 a_15828_12612# VDD 0.14807f
C3371 a_6308_14180# a_5948_14136# 0.08707f
C3372 a_6644_4392# VDD 0.22827f
C3373 a_17708_7431# a_17620_7528# 0.30831f
C3374 a_14236_7864# VDD 0.34473f
C3375 a_2812_4295# a_3172_4392# 0.08717f
C3376 a_18492_9432# a_18604_8999# 0.02634f
C3377 a_2276_17316# a_2364_17272# 0.30831f
C3378 a_17956_6340# a_17596_6296# 0.08717f
C3379 a_10116_3204# a_10204_3160# 0.30831f
C3380 a_11012_11528# a_11424_11115# 0.72307f
C3381 a_8772_3204# dvo[3] 0.04421f
C3382 a_2724_9476# VDD 0.23014f
C3383 a_6308_11044# VDD 0.22854f
C3384 a_6308_12612# VDD 0.22854f
C3385 a_21628_17272# a_21516_16839# 0.02634f
C3386 a_8524_7431# VDD 0.35942f
C3387 a_7204_7908# a_6844_7864# 0.08707f
C3388 wire12.I a_9104_11875# 0.07023f
C3389 a_14124_4295# a_14036_4392# 0.30831f
C3390 a_2364_1159# a_2276_1256# 0.30831f
C3391 a_14596_1636# VDD 0.22854f
C3392 a_2364_13703# VDD 0.32958f
C3393 a_7292_3160# a_7180_2727# 0.02634f
C3394 a_2724_5960# VDD 0.23014f
C3395 a_1828_16936# VDD 0.2258f
C3396 a_9756_9432# VDD 0.34391f
C3397 a_18852_14180# a_18492_14136# 0.08717f
C3398 a_2812_8999# a_3172_9096# 0.08717f
C3399 a_18740_15368# VDD 0.23551f
C3400 a_10116_7908# a_10204_7864# 0.30831f
C3401 a_1380_15748# a_1020_15704# 0.08707f
C3402 a_4068_12612# a_4156_12568# 0.30831f
C3403 a_18156_12135# VDD 0.34965f
C3404 a_1020_1159# VDD 0.33f
C3405 a_3620_4772# a_3260_4728# 0.08707f
C3406 a_13340_1159# a_13700_1256# 0.08717f
C3407 a_14236_3160# a_14124_2727# 0.02634f
C3408 a_4940_8999# VDD 0.34876f
C3409 a_3172_17316# VDD 0.23525f
C3410 a_11012_3204# VDD 0.23344f
C3411 a_14124_8999# a_14036_9096# 0.30831f
C3412 a_18940_17272# VDD 0.34791f
C3413 a_16908_16623# VDD 0.4036f
C3414 a_10116_14180# VDD 0.23324f
C3415 input1.Z a_20732_9432# 0.04613f
C3416 a_13476_17316# a_13116_17272# 0.0869f
C3417 a_7292_7864# a_7180_7431# 0.02634f
C3418 a_15132_18407# a_15044_18504# 0.30831f
C3419 a_22076_3160# a_21964_2727# 0.02634f
C3420 a_18940_3160# VDD 0.35234f
C3421 a_20980_7528# VDD 0.22827f
C3422 a_10316_5863# a_10228_5960# 0.30831f
C3423 a_1828_9476# a_1468_9432# 0.08707f
C3424 a_5052_15704# VDD 0.34477f
C3425 a_20508_18407# VDD 0.34073f
C3426 a_14236_7864# a_14124_7431# 0.02634f
C3427 a_7292_4728# VDD 0.34473f
C3428 a_11012_4772# avo[2] 0.0387f
C3429 a_5860_11044# a_5500_11000# 0.0869f
C3430 a_10204_9432# avo[3] 0.04791f
C3431 a_14932_16936# a_14820_15748# 0.02666f
C3432 a_16812_12135# a_16724_12232# 0.30831f
C3433 a_19052_2727# VDD 0.35643f
C3434 a_21085_808# a_21709_808# 0.10782f
C3435 a_21068_5863# a_21428_5960# 0.0869f
C3436 a_18604_15704# VDD 0.36534f
C3437 a_22076_7864# a_21964_7431# 0.02634f
C3438 input2.Z a_16364_8999# 0.04791f
C3439 a_21092_4772# VDD 0.22854f
C3440 a_6732_2727# a_6644_2824# 0.30831f
C3441 a_17172_9096# VDD 0.22854f
C3442 a_21092_4772# a_21180_4728# 0.30831f
C3443 a_13700_1636# a_13340_1592# 0.08707f
C3444 a_932_3204# a_1020_3160# 0.30831f
C3445 a_3708_6296# VDD 0.37719f
C3446 a_1020_13703# a_932_13800# 0.30831f
C3447 a_11572_4392# a_11460_3204# 0.02666f
C3448 a_7628_10567# VDD 0.35733f
C3449 a_13028_14180# a_12668_14136# 0.08663f
C3450 a_15899_15423# a_16192_15011# 0.49886f
C3451 a_4852_15368# VDD 0.24963f
C3452 a_3260_15271# a_3172_15368# 0.30831f
C3453 a_15468_4295# VDD 0.34315f
C3454 a_17260_2727# a_17620_2824# 0.08707f
C3455 a_4940_12135# VDD 0.34876f
C3456 a_17508_1636# a_17596_1592# 0.30831f
C3457 a_9780_2824# VDD 0.22869f
C3458 a_18516_4392# a_18404_3204# 0.02666f
C3459 a_17508_6340# VDD 0.22881f
C3460 dac_div_chain\[3\]_inv_notouch_.ZN a_8996_13479# 0.1531f
C3461 a_10228_10664# VDD 0.23126f
C3462 a_6732_7431# a_6644_7528# 0.30831f
C3463 a_21092_9476# a_21180_9432# 0.30831f
C3464 a_7652_7908# VDD 0.22854f
C3465 a_13700_6340# a_13340_6296# 0.08707f
C3466 a_11572_9096# a_11460_7908# 0.02666f
C3467 a_2364_16839# a_2276_16936# 0.30831f
C3468 a_932_7908# a_1020_7864# 0.30831f
C3469 a_6756_3204# a_6844_3160# 0.30831f
C3470 a_4156_12135# a_4068_12232# 0.30831f
C3471 a_13228_10567# a_13588_10664# 0.08707f
C3472 a_3260_12568# a_3260_12135# 0.05841f
C3473 a_11660_5863# VDD 0.39825f
C3474 a_14708_12612# VDD 0.80921f
C3475 a_5860_14180# a_5948_14136# 0.30831f
C3476 a_17260_7431# a_17620_7528# 0.08707f
C3477 a_6196_4392# VDD 0.22827f
C3478 a_2812_4295# a_2724_4392# 0.30831f
C3479 a_13788_7864# VDD 0.34473f
C3480 a_17508_6340# a_17596_6296# 0.30831f
C3481 a_2276_17316# a_1916_17272# 0.08707f
C3482 a_10116_3204# a_9756_3160# 0.08707f
C3483 a_18516_9096# a_18404_7908# 0.02666f
C3484 a_15356_17272# a_15468_16839# 0.02634f
C3485 a_2276_9476# VDD 0.22866f
C3486 a_5860_11044# VDD 0.22854f
C3487 a_5860_12612# VDD 0.22854f
C3488 a_6756_7908# a_6844_7864# 0.30831f
C3489 wire12.I a_8176_12232# 0.09035f
C3490 a_13676_4295# a_14036_4392# 0.08707f
C3491 a_8076_7431# VDD 0.34315f
C3492 a_14148_1636# VDD 0.22854f
C3493 a_1916_1159# a_2276_1256# 0.08717f
C3494 a_1916_13703# VDD 0.32626f
C3495 a_2276_5960# VDD 0.22866f
C3496 a_1380_16936# VDD 0.2258f
C3497 a_6396_11000# a_6284_10567# 0.02634f
C3498 a_10228_2824# avo[3] 0.04906f
C3499 a_9308_9432# VDD 0.34315f
C3500 a_7988_2824# a_8100_1636# 0.02666f
C3501 a_18404_14180# a_18492_14136# 0.30831f
C3502 a_2812_8999# a_2724_9096# 0.30831f
C3503 a_4852_12232# a_4964_11044# 0.02666f
C3504 a_18292_15368# VDD 0.23339f
C3505 a_932_15748# a_1020_15704# 0.30831f
C3506 a_10116_7908# a_9756_7864# 0.08707f
C3507 a_17708_12135# VDD 0.34798f
C3508 a_4068_12612# a_3708_12568# 0.08707f
C3509 a_22076_1592# VDD 0.36965f
C3510 a_13340_1159# a_13252_1256# 0.30831f
C3511 a_3172_4772# a_3260_4728# 0.30831f
C3512 a_4156_8999# VDD 0.35632f
C3513 a_2724_17316# VDD 0.23516f
C3514 a_10564_3204# VDD 0.22827f
C3515 a_14932_2824# a_15044_1636# 0.02666f
C3516 a_13676_8999# a_14036_9096# 0.08707f
C3517 a_9668_14180# VDD 0.22831f
C3518 a_3172_15368# a_3172_14180# 0.05841f
C3519 a_13028_17316# a_13116_17272# 0.30831f
C3520 a_17280_16579# VDD 0.18897f
C3521 a_14684_18407# a_15044_18504# 0.08717f
C3522 a_7988_7528# a_8100_6340# 0.02666f
C3523 a_21876_2824# a_21988_1636# 0.02666f
C3524 a_18492_3160# VDD 0.34923f
C3525 a_20532_7528# VDD 0.24899f
C3526 input1.Z a_20620_8999# 0.05656f
C3527 a_9868_5863# a_10228_5960# 0.08707f
C3528 a_4604_15704# VDD 0.35949f
C3529 a_1380_9476# a_1468_9432# 0.30831f
C3530 a_10228_15368# a_10116_14180# 0.02666f
C3531 a_6844_4728# VDD 0.34473f
C3532 a_20060_18407# VDD 0.34668f
C3533 a_3260_15704# a_3260_15271# 0.05841f
C3534 a_5412_11044# a_5500_11000# 0.30831f
C3535 a_3260_4728# a_3260_4295# 0.05841f
C3536 ana_div_chain\[3\]_inv_notouch_.I ana_div_chain\[4\]_dff_notouch_.CLK 0.05038f
C3537 a_13924_15047# ana_div_chain\[3\]_inv_notouch_.ZN 0.14177f
C3538 a_14932_7528# a_15044_6340# 0.02666f
C3539 a_18604_2727# VDD 0.35143f
C3540 a_18156_15704# VDD 0.36308f
C3541 a_21068_5863# a_20980_5960# 0.30831f
C3542 a_20644_4772# VDD 0.22854f
C3543 a_2724_13800# a_2724_12612# 0.05841f
C3544 a_6284_2727# a_6644_2824# 0.08707f
C3545 ana_div_chain\[2\]_inv_notouch_.I a_11012_9476# 0.033f
C3546 a_10204_4728# a_10316_4295# 0.02634f
C3547 a_16724_9096# VDD 0.22854f
C3548 a_21092_4772# a_20732_4728# 0.0869f
C3549 a_21876_7528# a_21988_6340# 0.02666f
C3550 a_13252_1636# a_13340_1592# 0.30831f
C3551 a_8972_5863# dvo[3] 0.04613f
C3552 a_3260_6296# VDD 0.33422f
C3553 ana_div_chain\[2\]_dff_notouch_.Q a_13280_11485# 0.28502f
C3554 a_7180_10567# VDD 0.34315f
C3555 dac_div_chain\[4\]_inv_notouch_.I dac_div_chain\[4\]_dff_notouch_.D 0.3827f
C3556 a_12580_14180# a_12668_14136# 0.30831f
C3557 a_11366_10216# avo[2] 0.87323f
C3558 a_4068_15368# VDD 0.24448f
C3559 a_2364_9432# a_2364_8999# 0.05841f
C3560 a_2812_15271# a_3172_15368# 0.08717f
C3561 a_15020_4295# VDD 0.34315f
C3562 a_17260_2727# a_17172_2824# 0.30831f
C3563 a_18044_4728# a_18156_4295# 0.02634f
C3564 a_4156_12135# VDD 0.35632f
C3565 a_9332_2824# VDD 0.22869f
C3566 a_17508_1636# a_17148_1592# 0.08717f
C3567 a_17060_6340# VDD 0.22827f
C3568 a_10204_14136# a_8996_13479# 0.05791f
C3569 a_9780_10664# VDD 0.22944f
C3570 a_6284_7431# a_6644_7528# 0.08707f
C3571 a_21092_9476# a_20732_9432# 0.0869f
C3572 a_7204_7908# VDD 0.22854f
C3573 a_9756_9432# a_9868_8999# 0.02634f
C3574 a_13252_6340# a_13340_6296# 0.30831f
C3575 a_6756_3204# a_6396_3160# 0.08707f
C3576 a_1916_16839# a_2276_16936# 0.08717f
C3577 a_13228_10567# a_13140_10664# 0.30831f
C3578 a_3708_12135# a_4068_12232# 0.08717f
C3579 a_11212_5863# VDD 0.35295f
C3580 wire20.I VDD 0.47588f
C3581 a_11748_12568# VDD 0.4068f
C3582 a_17260_7431# a_17172_7528# 0.30831f
C3583 a_5860_14180# a_5500_14136# 0.08707f
C3584 dac_div_chain\[4\]_dff_notouch_.Q a_14372_15748# 0.05156f
C3585 a_5748_4392# VDD 0.22827f
C3586 a_18044_9432# a_18156_8999# 0.02634f
C3587 a_13340_7864# VDD 0.34474f
C3588 a_2364_4295# a_2724_4392# 0.08717f
C3589 a_17508_6340# a_17148_6296# 0.08717f
C3590 a_1828_17316# a_1916_17272# 0.30831f
C3591 a_9668_3204# a_9756_3160# 0.30831f
C3592 a_1828_9476# VDD 0.2258f
C3593 a_5412_11044# VDD 0.22854f
C3594 ana_div_chain\[2\]_dff_notouch_.Q a_13272_13352# 0.03687f
C3595 a_5412_12612# VDD 0.22854f
C3596 a_21180_17272# a_21068_16839# 0.02634f
C3597 a_15380_16936# dvo[0] 0.05142f
C3598 a_7628_7431# VDD 0.34315f
C3599 a_13676_4295# a_13588_4392# 0.30831f
C3600 a_6756_7908# a_6396_7864# 0.08707f
C3601 a_11212_7431# avo[2] 0.05714f
C3602 a_1916_1159# a_1828_1256# 0.30831f
C3603 a_1468_13703# VDD 0.32605f
C3604 a_13700_1636# VDD 0.22854f
C3605 a_1828_5960# VDD 0.2258f
C3606 a_6844_3160# a_6732_2727# 0.02634f
C3607 a_932_16936# VDD 0.24399f
C3608 a_8860_9432# VDD 0.34777f
C3609 a_18404_14180# a_18044_14136# 0.08717f
C3610 a_10228_10664# avo[3] 0.04529f
C3611 a_2364_8999# a_2724_9096# 0.08717f
C3612 a_17844_15368# VDD 0.23188f
C3613 a_9668_7908# a_9756_7864# 0.30831f
C3614 a_3620_12612# a_3708_12568# 0.30831f
C3615 a_17260_12135# VDD 0.34521f
C3616 a_12892_1159# a_13252_1256# 0.08717f
C3617 a_3172_4772# a_2812_4728# 0.08707f
C3618 VDD dvo[2] 1.57224f
C3619 a_21628_1592# VDD 0.34147f
C3620 dac_div_chain\[3\]_inv_notouch_.ZN VDD 0.6236f
C3621 a_13788_3160# a_13676_2727# 0.02634f
C3622 a_3708_8999# VDD 0.37719f
C3623 a_2276_17316# VDD 0.23368f
C3624 a_10116_3204# VDD 0.22827f
C3625 a_13676_8999# a_13588_9096# 0.30831f
C3626 a_9220_14180# VDD 0.22827f
C3627 a_6844_7864# a_6732_7431# 0.02634f
C3628 a_14684_18407# a_14596_18504# 0.30831f
C3629 ana_div_chain\[2\]_dff_notouch_.Q a_13988_12071# 0.05601f
C3630 a_21628_3160# a_21516_2727# 0.02634f
C3631 a_18044_3160# VDD 0.34714f
C3632 a_19860_7528# VDD 0.23913f
C3633 a_1380_9476# a_1020_9432# 0.08707f
C3634 a_4156_15704# VDD 0.33493f
C3635 a_9868_5863# a_9780_5960# 0.30831f
C3636 a_19276_18407# VDD 0.41752f
C3637 a_13788_7864# a_13676_7431# 0.02634f
C3638 a_6396_4728# VDD 0.34473f
C3639 a_5412_11044# a_5052_11000# 0.0869f
C3640 a_15848_17776# ana_div_chain\[4\]_dff_notouch_.CLK 0.23577f
C3641 ana_div_chain\[3\]_inv_notouch_.I ana_div_chain\[4\]_inv_notouch_.ZN 0.20163f
C3642 a_14484_16936# a_14372_15748# 0.02666f
C3643 a_13924_15047# a_14336_15368# 0.72261f
C3644 a_4068_4392# a_4068_3204# 0.05841f
C3645 a_18156_2727# VDD 0.34917f
C3646 a_20620_5863# a_20980_5960# 0.0869f
C3647 a_20755_808# VDD 0.31796f
C3648 a_17708_15704# VDD 0.36176f
C3649 a_6284_2727# a_6196_2824# 0.30831f
C3650 a_21628_7864# a_21516_7431# 0.02634f
C3651 a_20196_4772# VDD 0.23094f
C3652 ana_div_chain\[2\]_inv_notouch_.I a_10564_9476# 0.03412f
C3653 a_16276_9096# VDD 0.23094f
C3654 a_20644_4772# a_20732_4728# 0.30831f
C3655 a_13252_1636# a_12892_1592# 0.08707f
C3656 a_2812_6296# VDD 0.33144f
C3657 a_11124_4392# a_11012_3204# 0.02666f
C3658 a_10564_3204# avo[3] 0.03114f
C3659 a_6732_10567# VDD 0.34315f
C3660 a_12580_14180# a_12220_14136# 0.0869f
C3661 a_10764_10567# avo[2] 0.06829f
C3662 a_3620_15368# VDD 0.25323f
C3663 a_2812_15271# a_2724_15368# 0.30831f
C3664 a_14572_4295# VDD 0.34315f
C3665 a_16812_2727# a_17172_2824# 0.08707f
C3666 a_3708_12135# VDD 0.37719f
C3667 a_4068_9096# a_4068_7908# 0.05841f
C3668 a_8884_2824# VDD 0.22869f
C3669 a_17060_1636# a_17148_1592# 0.30831f
C3670 a_21852_14136# a_21740_13703# 0.02634f
C3671 a_18068_4392# a_17956_3204# 0.02666f
C3672 a_16612_6340# VDD 0.24899f
C3673 a_9332_10664# VDD 0.14128f
C3674 a_6284_7431# a_6196_7528# 0.30831f
C3675 a_18492_14136# a_18492_13703# 0.05841f
C3676 a_20644_9476# a_20732_9432# 0.30831f
C3677 a_6756_7908# VDD 0.22854f
C3678 a_13252_6340# a_12892_6296# 0.08707f
C3679 a_11124_9096# a_11012_7908# 0.02666f
C3680 a_1916_16839# a_1828_16936# 0.30831f
C3681 a_6308_3204# a_6396_3160# 0.30831f
C3682 a_12780_10567# a_13140_10664# 0.08707f
C3683 a_3708_12135# a_3620_12232# 0.30831f
C3684 a_10764_5863# VDD 0.351f
C3685 a_12692_13800# VDD 0.25087f
C3686 a_2812_12568# a_2812_12135# 0.05841f
C3687 a_16812_7431# a_17172_7528# 0.08707f
C3688 a_5300_4392# VDD 0.22827f
C3689 a_5412_14180# a_5500_14136# 0.30831f
C3690 a_12892_7864# VDD 0.34477f
C3691 a_2364_4295# a_2276_4392# 0.30831f
C3692 a_17060_6340# a_17148_6296# 0.30831f
C3693 a_1828_17316# a_1468_17272# 0.08707f
C3694 a_18068_9096# a_17956_7908# 0.02666f
C3695 a_9668_3204# a_9308_3160# 0.08707f
C3696 a_14908_17272# a_15020_16839# 0.02634f
C3697 a_1380_9476# VDD 0.2258f
C3698 a_4964_11044# VDD 0.22854f
C3699 a_4964_12612# VDD 0.22854f
C3700 a_6308_7908# a_6396_7864# 0.30831f
C3701 a_7180_7431# VDD 0.34315f
C3702 a_13228_4295# a_13588_4392# 0.08707f
C3703 a_1468_1159# a_1828_1256# 0.08717f
C3704 a_1020_13703# VDD 0.33f
C3705 a_13252_1636# VDD 0.22854f
C3706 a_1380_5960# VDD 0.2258f
C3707 a_5948_11000# a_5836_10567# 0.02634f
C3708 a_15940_16615# VDD 2.25748f
C3709 a_15604_9476# VDD 0.2373f
C3710 a_7540_2824# a_7652_1636# 0.02666f
C3711 a_17956_14180# a_18044_14136# 0.30831f
C3712 a_2364_8999# a_2276_9096# 0.30831f
C3713 a_17396_15368# VDD 0.20009f
C3714 a_9668_7908# a_9308_7864# 0.08707f
C3715 dac_div_chain\[2\]_load_slew11.Z a_7764_11911# 0.0699f
C3716 a_3620_12612# a_3260_12568# 0.08707f
C3717 a_16812_12135# VDD 0.34718f
C3718 a_2724_4772# a_2812_4728# 0.30831f
C3719 a_21180_1592# VDD 0.34145f
C3720 a_12892_1159# a_12804_1256# 0.30831f
C3721 a_10204_14136# VDD 0.34166f
C3722 input2.Z a_16724_4392# 0.03114f
C3723 a_3260_8999# VDD 0.33424f
C3724 a_1828_17316# VDD 0.23087f
C3725 a_14484_2824# a_14596_1636# 0.02666f
C3726 a_9668_3204# VDD 0.22827f
C3727 a_13228_8999# a_13588_9096# 0.08707f
C3728 a_8772_14180# VDD 0.24899f
C3729 a_2724_15368# a_2724_14180# 0.05841f
C3730 a_14236_18407# a_14596_18504# 0.08717f
C3731 a_7540_7528# a_7652_6340# 0.02666f
C3732 a_9104_11875# a_8732_11919# 0.10745f
C3733 a_8176_12232# a_9739_12287# 0.41635f
C3734 a_17596_3160# VDD 0.34462f
C3735 a_21428_2824# a_21540_1636# 0.02666f
C3736 a_19412_7528# VDD 0.28341f
C3737 a_16611_808# dac_vco_in 0.04528f
C3738 a_3708_15704# VDD 0.37719f
C3739 a_2812_15704# a_2812_15271# 0.05841f
C3740 a_9420_5863# a_9780_5960# 0.08707f
C3741 a_15716_15748# a_15804_15704# 0.30831f
C3742 a_9780_15368# a_9668_14180# 0.02666f
C3743 a_18828_18407# VDD 0.34414f
C3744 a_5948_4728# VDD 0.34473f
C3745 a_4964_11044# a_5052_11000# 0.30831f
C3746 a_2812_4728# a_2812_4295# 0.05841f
C3747 a_14484_7528# a_14596_6340# 0.02666f
C3748 a_15356_17272# ana_div_chain\[4\]_dff_notouch_.CLK 0.12401f
C3749 ana_div_chain\[3\]_inv_notouch_.I a_16352_16936# 0.09404f
C3750 a_17708_2727# VDD 0.3475f
C3751 a_15828_11044# VDD 0.23157f
C3752 a_20060_1159# VDD 0.37477f
C3753 a_16700_15704# VDD 0.36294f
C3754 a_20620_5863# a_20532_5960# 0.30831f
C3755 a_5836_2727# a_6196_2824# 0.08707f
C3756 a_19748_4772# VDD 0.2357f
C3757 a_2276_13800# a_2276_12612# 0.05841f
C3758 dvo[2] avo[3] 0.09866f
C3759 a_20644_4772# a_20284_4728# 0.0869f
C3760 a_9756_4728# a_9868_4295# 0.02634f
C3761 a_15828_9096# VDD 0.22827f
C3762 a_21428_7528# a_21540_6340# 0.02666f
C3763 a_12804_1636# a_12892_1592# 0.30831f
C3764 a_2364_6296# VDD 0.32958f
C3765 a_6284_10567# VDD 0.34315f
C3766 a_12132_14180# a_12220_14136# 0.30831f
C3767 ana_div_chain\[2\]_dff_notouch_.Q wire18.I 0.52548f
C3768 a_3172_15368# VDD 0.23225f
C3769 a_15604_9476# a_15692_9432# 0.30831f
C3770 a_2364_15271# a_2724_15368# 0.08717f
C3771 a_1916_9432# a_1916_8999# 0.05841f
C3772 a_16812_2727# a_16724_2824# 0.30831f
C3773 a_14124_4295# VDD 0.34315f
C3774 a_3260_12135# VDD 0.33424f
C3775 a_17596_4728# a_17708_4295# 0.02634f
C3776 a_22076_11000# a_21964_10567# 0.02634f
C3777 a_20896_13053# a_20603_12729# 0.49886f
C3778 a_8436_2824# VDD 0.23164f
C3779 a_17060_1636# a_16700_1592# 0.08717f
C3780 a_16028_6296# VDD 0.37312f
C3781 a_7988_10664# VDD 0.23004f
C3782 a_5836_7431# a_6196_7528# 0.08707f
C3783 a_20644_9476# a_20284_9432# 0.0869f
C3784 a_6308_7908# VDD 0.22854f
C3785 a_9308_9432# a_9420_8999# 0.02634f
C3786 a_12804_6340# a_12892_6296# 0.30831f
C3787 a_13924_15047# ana_div_chain\[2\]_dff_notouch_.Q 0.5152f
C3788 a_6308_3204# a_5948_3160# 0.08707f
C3789 a_1468_16839# a_1828_16936# 0.08717f
C3790 a_12780_10567# a_12692_10664# 0.30831f
C3791 a_3260_12135# a_3620_12232# 0.08717f
C3792 a_10316_5863# VDD 0.34802f
C3793 a_16812_7431# a_16724_7528# 0.30831f
C3794 a_5412_14180# a_5052_14136# 0.08707f
C3795 a_4852_4392# VDD 0.24963f
C3796 dac_div_chain\[4\]_dff_notouch_.Q a_13168_16189# 0.23651f
C3797 a_12444_7864# VDD 0.35949f
C3798 a_1916_4295# a_2276_4392# 0.08717f
C3799 a_17596_9432# a_17708_8999# 0.02634f
C3800 a_17060_6340# a_16700_6296# 0.08717f
C3801 a_1380_17316# a_1468_17272# 0.30831f
C3802 a_9220_3204# a_9308_3160# 0.30831f
C3803 a_4516_11044# VDD 0.23094f
C3804 a_4516_12612# VDD 0.23094f
C3805 a_20732_17272# a_20620_16839# 0.02634f
C3806 a_13228_4295# a_13140_4392# 0.30831f
C3807 a_6732_7431# VDD 0.34315f
C3808 a_6308_7908# a_5948_7864# 0.08707f
C3809 a_1468_1159# a_1380_1256# 0.30831f
C3810 a_21852_14136# VDD 0.36509f
C3811 a_12804_1636# VDD 0.22854f
C3812 a_6396_3160# a_6284_2727# 0.02634f
C3813 a_15468_16839# VDD 0.35458f
C3814 a_15156_9476# VDD 0.23184f
C3815 a_17956_14180# a_17596_14136# 0.08717f
C3816 input1.Z a_20420_14180# 0.79954f
C3817 a_3956_18504# a_4068_17316# 0.02666f
C3818 a_1916_8999# a_2276_9096# 0.08717f
C3819 a_4068_12232# a_4068_11044# 0.05841f
C3820 a_9220_7908# a_9308_7864# 0.30831f
C3821 a_14776_11919# VDD 0.18904f
C3822 a_3172_12612# a_3260_12568# 0.30831f
C3823 a_12444_1159# a_12804_1256# 0.08717f
C3824 a_7988_10664# a_8100_9476# 0.02666f
C3825 a_2724_4772# a_2364_4728# 0.08707f
C3826 a_20732_1592# VDD 0.34132f
C3827 a_9756_14136# VDD 0.34853f
C3828 a_13340_3160# a_13228_2727# 0.02634f
C3829 a_12640_12932# dac_div_chain\[1\]_inv_notouch_.ZN 0.22419f
C3830 a_2812_8999# VDD 0.33144f
C3831 a_9220_3204# VDD 0.22827f
C3832 a_1380_17316# VDD 0.23055f
C3833 a_13228_8999# a_13140_9096# 0.30831f
C3834 a_8188_14136# VDD 0.37341f
C3835 a_6396_7864# a_6284_7431# 0.02634f
C3836 a_14236_18407# a_14148_18504# 0.30831f
C3837 a_21180_3160# a_21068_2727# 0.02634f
C3838 a_8176_12232# a_8732_11919# 0.83991f
C3839 a_17148_3160# VDD 0.34315f
C3840 input2.Z a_16612_1636# 0.05125f
C3841 a_18964_7528# VDD 0.23661f
C3842 a_9420_5863# a_9332_5960# 0.30831f
C3843 a_3260_15704# VDD 0.33422f
C3844 a_15716_15748# a_15356_15704# 0.0869f
C3845 a_18380_18407# VDD 0.33983f
C3846 a_13340_7864# a_13228_7431# 0.02634f
C3847 a_5500_4728# VDD 0.34475f
C3848 a_4964_11044# a_4604_11000# 0.0869f
C3849 a_3620_4392# a_3620_3204# 0.05841f
C3850 a_15380_11044# VDD 0.22954f
C3851 a_17260_2727# VDD 0.34473f
C3852 a_14432_11875# a_16724_12232# 0.08674f
C3853 a_20662_13352# avo[1] 0.85414f
C3854 ana_div_chain\[3\]_inv_notouch_.I a_13924_15047# 0.11377f
C3855 a_21652_15748# VDD 0.23674f
C3856 a_19276_1159# VDD 0.4157f
C3857 a_5836_2727# a_5748_2824# 0.30831f
C3858 a_21180_7864# a_21068_7431# 0.02634f
C3859 a_19300_4772# VDD 0.28063f
C3860 a_15380_9096# VDD 0.22827f
C3861 a_20196_4772# a_20284_4728# 0.30831f
C3862 a_12804_1636# a_12444_1592# 0.08707f
C3863 a_10676_4392# a_10564_3204# 0.02666f
C3864 a_1916_6296# VDD 0.32626f
C3865 a_5836_10567# VDD 0.34315f
C3866 a_15264_15011# a_14892_15055# 0.10745f
C3867 a_12132_14180# a_11772_14136# 0.0869f
C3868 a_15604_9476# a_15244_9432# 0.08663f
C3869 a_2724_15368# VDD 0.23014f
C3870 a_2364_15271# a_2276_15368# 0.30831f
C3871 a_13676_4295# VDD 0.34315f
C3872 dac_div_chain\[2\]_dff_notouch_.D a_8732_11919# 0.21093f
C3873 a_16364_2727# a_16724_2824# 0.08707f
C3874 a_2812_12135# VDD 0.33144f
C3875 a_3620_9096# a_3620_7908# 0.05841f
C3876 a_7988_2824# VDD 0.22842f
C3877 a_16612_1636# a_16700_1592# 0.30831f
C3878 a_17620_4392# a_17508_3204# 0.02666f
C3879 a_15580_6296# VDD 0.34473f
C3880 a_7540_10664# VDD 0.22827f
C3881 a_5836_7431# a_5748_7528# 0.30831f
C3882 a_18044_14136# a_18044_13703# 0.05841f
C3883 a_20196_9476# a_20284_9432# 0.30831f
C3884 a_5860_7908# VDD 0.22854f
C3885 a_12804_6340# a_12444_6296# 0.08707f
C3886 a_8188_14136# a_8076_13703# 0.02634f
C3887 a_10676_9096# a_10564_7908# 0.02666f
C3888 a_5860_3204# a_5948_3160# 0.30831f
C3889 a_1468_16839# a_1380_16936# 0.30831f
C3890 a_3260_12135# a_3172_12232# 0.30831f
C3891 a_2364_12568# a_2364_12135# 0.05841f
C3892 a_9868_5863# VDD 0.34671f
C3893 a_4068_4392# VDD 0.24448f
C3894 a_4964_14180# a_5052_14136# 0.30831f
C3895 a_16364_7431# a_16724_7528# 0.08707f
C3896 a_11996_7864# VDD 0.34951f
C3897 a_1916_4295# a_1828_4392# 0.30831f
C3898 a_16612_6340# a_16700_6296# 0.30831f
C3899 a_1380_17316# a_1020_17272# 0.08707f
C3900 a_9220_3204# a_8860_3160# 0.08707f
C3901 a_17620_9096# a_17508_7908# 0.02666f
C3902 a_14460_17272# a_14572_16839# 0.02634f
C3903 a_4068_11044# VDD 0.23872f
C3904 a_4068_12612# VDD 0.23871f
C3905 input1.Z a_20532_12232# 0.04971f
C3906 a_6284_7431# VDD 0.34315f
C3907 a_5860_7908# a_5948_7864# 0.30831f
C3908 a_12780_4295# a_13140_4392# 0.08707f
C3909 a_1020_1159# a_1380_1256# 0.08717f
C3910 a_12356_1636# VDD 0.23094f
C3911 a_21404_14136# VDD 0.34453f
C3912 input1.Z a_20532_4392# 0.0441f
C3913 a_5500_11000# a_5388_10567# 0.02634f
C3914 a_15020_16839# VDD 0.34483f
C3915 a_14708_9476# VDD 0.23173f
C3916 a_7092_2824# a_7204_1636# 0.02666f
C3917 a_11100_9432# avo[2] 0.04791f
C3918 a_17508_14180# a_17596_14136# 0.30831f
C3919 a_1916_8999# a_1828_9096# 0.30831f
C3920 a_14880_11875# VDD 0.40375f
C3921 a_9220_7908# a_8860_7864# 0.08707f
C3922 a_3172_12612# a_2812_12568# 0.08707f
C3923 a_2276_4772# a_2364_4728# 0.30831f
C3924 a_20284_1592# VDD 0.35822f
C3925 a_12444_1159# a_12356_1256# 0.30831f
C3926 a_9308_14136# VDD 0.34919f
C3927 a_932_4772# VDD 0.24399f
C3928 a_12152_12637# dac_div_chain\[1\]_inv_notouch_.ZN 0.25128f
C3929 a_12640_12932# a_12536_13097# 0.10745f
C3930 a_2364_8999# VDD 0.32958f
C3931 a_10316_5863# avo[3] 0.05714f
C3932 dac_div_chain\[0\]_inv_notouch_.ZN wire20.I 0.11831f
C3933 a_932_17316# VDD 0.24589f
C3934 a_8772_3204# VDD 0.24899f
C3935 input1.Z a_20644_1636# 0.05679f
C3936 a_14036_2824# a_14148_1636# 0.02666f
C3937 ana_div_chain\[2\]_inv_notouch_.I ana_div_chain\[2\]_inv_notouch_.ZN 0.27149f
C3938 a_12780_8999# a_13140_9096# 0.08707f
C3939 a_7740_14136# VDD 0.34473f
C3940 a_2276_15368# a_2276_14180# 0.05841f
C3941 input2.Z dvo[0] 0.03099f
C3942 a_6051_18100# uio_oe[3] 0.04649f
C3943 a_13788_18407# a_14148_18504# 0.08717f
C3944 a_7092_7528# a_7204_6340# 0.02666f
C3945 a_8176_12232# a_9104_11875# 1.16478f
C3946 uio_oe[4] uio_oe[3] 0.06034f
C3947 a_20980_2824# a_21092_1636# 0.02666f
C3948 a_16700_3160# VDD 0.34777f
C3949 a_18516_7528# VDD 0.23398f
C3950 a_8972_5863# a_9332_5960# 0.08707f
C3951 a_9332_15368# a_9220_14180# 0.02666f
C3952 a_15268_15748# a_15356_15704# 0.30831f
C3953 a_2812_15704# VDD 0.33144f
C3954 a_2364_15704# a_2364_15271# 0.05841f
C3955 a_5052_4728# VDD 0.34477f
C3956 a_17752_18101# VDD 0.45358f
C3957 a_2364_4728# a_2364_4295# 0.05841f
C3958 a_15940_4772# a_16028_4728# 0.30831f
C3959 a_4516_11044# a_4604_11000# 0.30831f
C3960 a_14036_7528# a_14148_6340# 0.02666f
C3961 a_16812_2727# VDD 0.34473f
C3962 a_14932_11044# VDD 0.14856f
C3963 a_19768_13397# avo[1] 0.56218f
C3964 a_19948_5863# a_19860_5960# 0.30831f
C3965 a_18828_1159# VDD 0.35188f
C3966 a_21204_15748# VDD 0.23129f
C3967 a_1828_13800# a_1828_12612# 0.05841f
C3968 a_5388_2727# a_5748_2824# 0.08707f
C3969 a_18852_4772# VDD 0.2354f
C3970 input2.Z ana_div_chain\[1\]_dff_notouch_.CLK 0.72516f
C3971 a_14932_9096# VDD 0.22827f
C3972 a_9308_4728# a_9420_4295# 0.02634f
C3973 a_20196_4772# a_19836_4728# 0.0869f
C3974 a_12356_1636# a_12444_1592# 0.30831f
C3975 a_20980_7528# a_21092_6340# 0.02666f
C3976 a_1468_6296# VDD 0.32605f
C3977 dac_div_chain\[1\]_dff_notouch_.CLK a_12192_13053# 0.51084f
C3978 a_5388_10567# VDD 0.34317f
C3979 a_11684_14180# a_11772_14136# 0.30831f
C3980 a_1916_15271# a_2276_15368# 0.08717f
C3981 a_2276_15368# VDD 0.22866f
C3982 a_1468_9432# a_1468_8999# 0.05841f
C3983 a_15156_9476# a_15244_9432# 0.30831f
C3984 a_13228_4295# VDD 0.34317f
C3985 a_16364_2727# a_16276_2824# 0.30831f
C3986 a_2364_12135# VDD 0.32958f
C3987 a_17148_4728# a_17260_4295# 0.02634f
C3988 a_21628_11000# a_21516_10567# 0.02634f
C3989 a_7540_2824# VDD 0.22842f
C3990 a_15132_6296# VDD 0.34473f
C3991 a_7092_10664# VDD 0.22827f
C3992 a_5388_7431# a_5748_7528# 0.08707f
C3993 a_13228_15271# a_13140_15368# 0.30831f
C3994 a_5412_7908# VDD 0.22854f
C3995 a_20196_9476# a_19836_9432# 0.0869f
C3996 a_8860_9432# a_8972_8999# 0.02634f
C3997 a_12356_6340# a_12444_6296# 0.30831f
C3998 VDD ana_vco_in 0.27326f
C3999 a_1020_16839# a_1380_16936# 0.08717f
C4000 a_5860_3204# a_5500_3160# 0.08707f
C4001 a_2812_12135# a_3172_12232# 0.08717f
C4002 a_9420_5863# VDD 0.34473f
C4003 a_4964_14180# a_4604_14136# 0.08707f
C4004 a_3620_4392# VDD 0.25323f
C4005 a_16364_7431# a_16276_7528# 0.30831f
C4006 a_17148_9432# a_17260_8999# 0.02634f
C4007 a_1468_4295# a_1828_4392# 0.08717f
C4008 a_11548_7864# VDD 0.40851f
C4009 a_932_17316# a_1020_17272# 0.30831f
C4010 a_8772_3204# a_8860_3160# 0.30831f
C4011 a_3620_11044# VDD 0.25323f
C4012 a_3620_12612# VDD 0.25323f
C4013 a_12780_4295# a_12692_4392# 0.30831f
C4014 a_5860_7908# a_5500_7864# 0.08707f
C4015 a_5836_7431# VDD 0.34315f
C4016 a_11908_1636# VDD 0.23801f
C4017 a_19836_14136# VDD 0.36279f
C4018 a_5948_3160# a_5836_2727# 0.02634f
C4019 a_14572_16839# VDD 0.34483f
C4020 a_14260_9476# VDD 0.23182f
C4021 ana_div_chain\[4\]_dff_notouch_.Q a_18852_17316# 0.05732f
C4022 a_17508_14180# a_17148_14136# 0.08717f
C4023 a_3508_18504# a_3620_17316# 0.02666f
C4024 a_1468_8999# a_1828_9096# 0.08717f
C4025 a_3620_12232# a_3620_11044# 0.05841f
C4026 a_8772_7908# a_8860_7864# 0.30831f
C4027 a_14392_12243# VDD 1.12417f
C4028 a_2724_12612# a_2812_12568# 0.30831f
C4029 a_19836_1592# VDD 0.36183f
C4030 a_2276_4772# a_1916_4728# 0.08707f
C4031 a_7540_10664# a_7652_9476# 0.02666f
C4032 a_12892_3160# a_12780_2727# 0.02634f
C4033 a_21876_5960# VDD 0.23402f
C4034 a_8860_14136# VDD 0.36136f
C4035 a_12192_13053# dac_div_chain\[1\]_inv_notouch_.ZN 0.16399f
C4036 a_12152_12637# a_12536_13097# 1.16478f
C4037 a_1916_8999# VDD 0.32626f
C4038 a_8188_3160# VDD 0.37312f
C4039 a_21764_18504# VDD 0.23673f
C4040 a_12780_8999# a_12692_9096# 0.30831f
C4041 a_7292_14136# VDD 0.34473f
C4042 a_15398_14516# dvo[0] 0.47159f
C4043 a_5948_7864# a_5836_7431# 0.02634f
C4044 a_13788_18407# a_13700_18504# 0.30831f
C4045 a_20732_3160# a_20620_2727# 0.02634f
C4046 a_21988_3204# VDD 0.23471f
C4047 a_18068_7528# VDD 0.23212f
C4048 a_8972_5863# a_8884_5960# 0.30831f
C4049 a_2364_15704# VDD 0.32958f
C4050 a_15268_15748# a_14908_15704# 0.0869f
C4051 a_4604_4728# VDD 0.35949f
C4052 a_12892_7864# a_12780_7431# 0.02634f
C4053 a_17148_18407# VDD 0.3481f
C4054 a_4516_11044# a_4156_11000# 0.0869f
C4055 a_15940_4772# a_15580_4728# 0.08663f
C4056 a_3172_4392# a_3172_3204# 0.05841f
C4057 a_12987_11161# VDD 0.37869f
C4058 a_16364_2727# VDD 0.35942f
C4059 a_19500_5863# a_19860_5960# 0.08663f
C4060 a_18380_1159# VDD 0.34901f
C4061 a_20756_15748# VDD 0.23129f
C4062 a_18404_4772# VDD 0.23318f
C4063 a_20732_7864# a_20620_7431# 0.02634f
C4064 a_5388_2727# a_5300_2824# 0.30831f
C4065 a_19748_4772# a_19836_4728# 0.30831f
C4066 a_14484_9096# VDD 0.22827f
C4067 ana_div_chain\[4\]_dff_notouch_.CLK VDD 0.54839f
C4068 a_12356_1636# a_11996_1592# 0.08707f
C4069 a_1020_6296# VDD 0.33f
C4070 a_10228_4392# a_10116_3204# 0.02666f
C4071 a_4940_10567# VDD 0.34876f
C4072 a_11684_14180# a_11324_14136# 0.0869f
C4073 a_8860_7864# dvo[3] 0.05656f
C4074 a_15156_9476# a_14796_9432# 0.08717f
C4075 a_1916_15271# a_1828_15368# 0.30831f
C4076 a_1828_15368# VDD 0.2258f
C4077 a_15916_2727# a_16276_2824# 0.08707f
C4078 a_12780_4295# VDD 0.3478f
C4079 dac_div_chain\[2\]_dff_notouch_.D a_8176_12232# 0.25128f
C4080 a_1916_12135# VDD 0.32626f
C4081 a_3172_9096# a_3172_7908# 0.05841f
C4082 a_7092_2824# VDD 0.22842f
C4083 a_19040_12683# a_20603_12729# 0.41635f
C4084 a_17172_4392# a_17060_3204# 0.02666f
C4085 a_14684_6296# VDD 0.34473f
C4086 a_6644_10664# VDD 0.22827f
C4087 input1.Z a_20603_12729# 0.08359f
C4088 a_5388_7431# a_5300_7528# 0.30831f
C4089 a_19748_9476# a_19836_9432# 0.30831f
C4090 a_17596_14136# a_17596_13703# 0.05841f
C4091 a_4964_7908# VDD 0.22854f
C4092 a_12780_15271# a_13140_15368# 0.08674f
C4093 a_7740_14136# a_7628_13703# 0.02634f
C4094 a_12356_6340# a_11996_6296# 0.08707f
C4095 a_5412_3204# a_5500_3160# 0.30831f
C4096 a_10228_9096# a_10116_7908# 0.02666f
C4097 a_1020_16839# a_932_16936# 0.30831f
C4098 a_10764_10567# a_10676_10664# 0.30831f
C4099 a_2812_12135# a_2724_12232# 0.30831f
C4100 a_1916_12568# a_1916_12135# 0.05841f
C4101 a_8972_5863# VDD 0.34473f
C4102 a_4516_14180# a_4604_14136# 0.30831f
C4103 a_15916_7431# a_16276_7528# 0.08707f
C4104 a_3172_4392# VDD 0.23225f
C4105 a_1468_4295# a_1380_4392# 0.30831f
C4106 dac_div_chain\[3\]_inv_notouch_.I dac_div_chain\[4\]_dff_notouch_.CLK 0.21594f
C4107 a_11100_7864# VDD 0.35005f
C4108 a_20980_16936# avo[0] 0.06196f
C4109 a_17172_9096# a_17060_7908# 0.02666f
C4110 a_14012_17272# a_14124_16839# 0.02634f
C4111 a_3172_11044# VDD 0.23225f
C4112 a_3172_12612# VDD 0.23225f
C4113 a_19836_17272# a_19948_16839# 0.02634f
C4114 a_5388_7431# VDD 0.34317f
C4115 a_5412_7908# a_5500_7864# 0.30831f
C4116 a_11460_1636# VDD 0.26719f
C4117 a_19388_14136# VDD 0.41942f
C4118 a_5052_11000# a_4940_10567# 0.02634f
C4119 a_14124_16839# VDD 0.34483f
C4120 a_13812_9476# VDD 0.23109f
C4121 dac_div_chain\[2\]_load_slew11.Z a_8792_10261# 0.20904f
C4122 a_17060_14180# a_17148_14136# 0.30831f
C4123 a_6644_2824# a_6756_1636# 0.02666f
C4124 a_17862_17744# a_18852_17316# 0.19634f
C4125 a_1468_8999# a_1380_9096# 0.30831f
C4126 a_21964_15271# VDD 0.37943f
C4127 a_14432_11875# VDD 2.21053f
C4128 a_2724_12612# a_2364_12568# 0.08707f
C4129 a_19388_1592# VDD 0.40582f
C4130 a_9868_18407# a_10419_18100# 0.03672f
C4131 a_1828_4772# a_1916_4728# 0.30831f
C4132 a_11772_1159# a_11684_1256# 0.30831f
C4133 a_21428_5960# VDD 0.22827f
C4134 a_1468_8999# VDD 0.32605f
C4135 a_12152_12637# a_12640_12932# 0.83991f
C4136 a_12192_13053# a_12536_13097# 0.08109f
C4137 a_21316_18504# VDD 0.23118f
C4138 a_7740_3160# VDD 0.34473f
C4139 a_13588_2824# a_13700_1636# 0.02666f
C4140 ana_div_chain\[2\]_inv_notouch_.I a_11012_11528# 0.10629f
C4141 a_1828_15368# a_1828_14180# 0.05841f
C4142 a_6844_14136# VDD 0.34473f
C4143 a_13340_18407# a_13700_18504# 0.08717f
C4144 a_6644_7528# a_6756_6340# 0.02666f
C4145 a_21540_3204# VDD 0.22854f
C4146 a_20532_2824# a_20644_1636# 0.02666f
C4147 a_17620_7528# VDD 0.22999f
C4148 a_8884_15368# a_8772_14180# 0.02666f
C4149 a_8524_5863# a_8884_5960# 0.08707f
C4150 a_1916_15704# a_1916_15271# 0.05841f
C4151 a_1916_15704# VDD 0.32626f
C4152 a_14820_15748# a_14908_15704# 0.30831f
C4153 a_4156_4728# VDD 0.33493f
C4154 a_16700_18407# VDD 0.3407f
C4155 a_15492_4772# a_15580_4728# 0.30831f
C4156 a_1916_4728# a_1916_4295# 0.05841f
C4157 a_4068_11044# a_4156_11000# 0.30831f
C4158 a_13588_7528# a_13700_6340# 0.02666f
C4159 a_15916_2727# VDD 0.34315f
C4160 a_13280_11485# VDD 0.71364f
C4161 a_17565_808# VDD 0.68972f
C4162 a_19500_5863# a_19412_5960# 0.30831f
C4163 a_20308_15748# VDD 0.23126f
C4164 a_17956_4772# VDD 0.23149f
C4165 a_1380_13800# a_1380_12612# 0.05841f
C4166 a_4940_2727# a_5300_2824# 0.08707f
C4167 a_8860_4728# a_8972_4295# 0.02634f
C4168 a_19748_4772# a_19388_4728# 0.08717f
C4169 a_14036_9096# VDD 0.22827f
C4170 a_21988_17316# VDD 0.23699f
C4171 a_11908_1636# a_11996_1592# 0.30831f
C4172 a_20532_7528# a_20644_6340# 0.02666f
C4173 ana_div_chain\[4\]_inv_notouch_.ZN VDD 0.41898f
C4174 a_8100_6340# VDD 0.23473f
C4175 a_4156_10567# VDD 0.35632f
C4176 a_11236_14180# a_11324_14136# 0.30831f
C4177 ana_div_chain\[2\]_dff_notouch_.Q dac_div_chain\[1\]_inv_notouch_.I 0.09341f
C4178 a_1020_9432# a_1020_8999# 0.05841f
C4179 a_14708_9476# a_14796_9432# 0.30831f
C4180 a_1380_15368# VDD 0.2258f
C4181 a_1468_15271# a_1828_15368# 0.08717f
C4182 a_15916_2727# a_15828_2824# 0.30831f
C4183 a_12108_4295# VDD 0.37606f
C4184 a_1468_12135# VDD 0.32605f
C4185 a_16700_4728# a_16812_4295# 0.02634f
C4186 a_21180_11000# a_21068_10567# 0.02634f
C4187 a_6644_2824# VDD 0.22842f
C4188 a_19968_13053# a_19596_13097# 0.10745f
C4189 a_18628_13096# a_20603_12729# 0.04722f
C4190 a_14236_6296# VDD 0.34473f
C4191 a_6196_10664# VDD 0.22827f
C4192 a_4940_7431# a_5300_7528# 0.08707f
C4193 a_19748_9476# a_19388_9432# 0.08717f
C4194 a_8772_1636# dvo[3] 0.05493f
C4195 a_12780_15271# a_12692_15368# 0.30831f
C4196 a_4516_7908# VDD 0.23094f
C4197 a_11908_6340# a_11996_6296# 0.30831f
C4198 dac_div_chain\[4\]_dff_notouch_.Q dvo[5] 0.03098f
C4199 a_14776_11919# ana_div_chain\[1\]_inv_notouch_.ZN 0.05149f
C4200 a_5412_3204# a_5052_3160# 0.08707f
C4201 a_10316_10567# a_10676_10664# 0.0869f
C4202 a_2364_12135# a_2724_12232# 0.08717f
C4203 a_8524_5863# VDD 0.35942f
C4204 a_13272_13352# VDD 0.73817f
C4205 a_4516_14180# a_4156_14136# 0.08707f
C4206 VDD uio_oe[0] 0.33772f
C4207 a_2724_4392# VDD 0.23014f
C4208 a_15916_7431# a_15828_7528# 0.30831f
C4209 a_16700_9432# a_16812_8999# 0.02634f
C4210 a_12356_18504# a_12038_17744# 0.03714f
C4211 a_10652_7864# VDD 0.34882f
C4212 a_1020_4295# a_1380_4392# 0.08717f
C4213 a_2724_11044# VDD 0.23014f
C4214 a_1011_18100# a_932_17316# 0.03636f
C4215 a_2724_12612# VDD 0.23014f
C4216 a_4940_7431# VDD 0.34876f
C4217 a_5412_7908# a_5052_7864# 0.08707f
C4218 a_12108_4295# a_12020_4392# 0.30831f
C4219 a_16028_6296# a_15916_5863# 0.02634f
C4220 a_11012_1636# VDD 0.23344f
C4221 a_18940_14136# VDD 0.36682f
C4222 a_5500_3160# a_5388_2727# 0.02634f
C4223 input1.Z a_20732_7864# 0.04613f
C4224 a_13364_9476# VDD 0.23136f
C4225 a_13676_16839# VDD 0.34483f
C4226 dac_div_chain\[2\]_load_slew11.Z a_8076_10567# 0.09912f
C4227 a_17060_14180# a_16700_14136# 0.08717f
C4228 a_1020_8999# a_1380_9096# 0.08717f
C4229 a_21516_15271# VDD 0.35817f
C4230 a_3172_12232# a_3172_11044# 0.05841f
C4231 a_13988_12071# VDD 0.37201f
C4232 a_21628_1592# a_21709_808# 0.0296f
C4233 ana_div_chain\[2\]_dff_notouch_.CLK VDD 0.52425f
C4234 a_11324_1159# a_11684_1256# 0.08717f
C4235 a_18940_1592# VDD 0.35392f
C4236 a_2276_12612# a_2364_12568# 0.30831f
C4237 a_7092_10664# a_7204_9476# 0.02666f
C4238 a_1828_4772# a_1468_4728# 0.08707f
C4239 a_20980_5960# VDD 0.22827f
C4240 a_1020_8999# VDD 0.33f
C4241 a_12192_13053# a_12640_12932# 0.22071f
C4242 a_20868_18504# VDD 0.23118f
C4243 a_7292_3160# VDD 0.34473f
C4244 a_12108_8999# a_12020_9096# 0.30831f
C4245 a_6396_14136# VDD 0.34473f
C4246 a_19860_16936# a_19860_15748# 0.05841f
C4247 a_13340_18407# a_13252_18504# 0.30831f
C4248 a_5500_7864# a_5388_7431# 0.02634f
C4249 ana_div_chain\[0\]_dff_notouch_.D a_19596_13097# 0.21609f
C4250 input2.Z a_16364_7431# 0.04791f
C4251 a_21092_3204# VDD 0.22854f
C4252 a_8996_13479# a_11264_13443# 0.03873f
C4253 a_17172_7528# VDD 0.22854f
C4254 a_8524_5863# a_8436_5960# 0.30831f
C4255 a_14820_15748# a_14460_15704# 0.0869f
C4256 a_1468_15704# VDD 0.32605f
C4257 a_16252_18407# VDD 0.34531f
C4258 a_3708_4728# VDD 0.37719f
C4259 a_15492_4772# a_15132_4728# 0.08707f
C4260 a_4068_11044# a_3708_11000# 0.08717f
C4261 a_2724_4392# a_2724_3204# 0.05841f
C4262 a_11980_11529# VDD 0.4091f
C4263 a_15468_2727# VDD 0.34315f
C4264 a_19052_5863# a_19412_5960# 0.08707f
C4265 a_16941_808# VDD 0.58447f
C4266 a_10900_16232# a_12780_15271# 0.03099f
C4267 a_19860_15748# VDD 0.2302f
C4268 a_17508_4772# VDD 0.22881f
C4269 a_4940_2727# a_4852_2824# 0.30831f
C4270 a_13588_9096# VDD 0.22827f
C4271 a_19300_4772# a_19388_4728# 0.30831f
C4272 a_21540_17316# VDD 0.23082f
C4273 a_11908_1636# a_11548_1592# 0.08707f
C4274 dac_div_chain\[1\]_dff_notouch_.CLK wire20.I 0.06715f
C4275 a_16352_16936# VDD 1.11137f
C4276 a_7652_6340# VDD 0.22854f
C4277 a_9780_4392# a_9668_3204# 0.02666f
C4278 a_3708_10567# VDD 0.37719f
C4279 ana_div_chain\[2\]_dff_notouch_.Q a_13384_11784# 0.10667f
C4280 a_14708_9476# a_14348_9432# 0.08717f
C4281 wire12.I a_8902_11472# 0.77501f
C4282 a_1468_15271# a_1380_15368# 0.30831f
C4283 a_932_15368# VDD 0.24399f
C4284 a_11660_4295# VDD 0.39825f
C4285 a_15468_2727# a_15828_2824# 0.08707f
C4286 a_1020_12135# VDD 0.33f
C4287 a_2724_9096# a_2724_7908# 0.05841f
C4288 a_6196_2824# VDD 0.22842f
C4289 a_19040_12683# a_19596_13097# 0.83991f
C4290 a_18628_13096# a_20896_13053# 0.03873f
C4291 input1.Z a_19596_13097# 0.03584f
C4292 a_16724_4392# a_16612_3204# 0.02666f
C4293 a_13788_6296# VDD 0.34473f
C4294 a_5748_10664# VDD 0.22827f
C4295 a_4940_7431# a_4852_7528# 0.30831f
C4296 a_17148_14136# a_17148_13703# 0.05841f
C4297 a_19300_9476# a_19388_9432# 0.30831f
C4298 a_4068_7908# VDD 0.23871f
C4299 a_7292_14136# a_7180_13703# 0.02634f
C4300 a_11908_6340# a_11548_6296# 0.08707f
C4301 a_12038_17744# dvo[5] 0.87866f
C4302 a_14880_11875# ana_div_chain\[1\]_inv_notouch_.ZN 0.24109f
C4303 a_9780_9096# a_9668_7908# 0.02666f
C4304 a_4964_3204# a_5052_3160# 0.30831f
C4305 a_10316_10567# a_10228_10664# 0.30831f
C4306 a_2364_12135# a_2276_12232# 0.30831f
C4307 a_12780_13703# VDD 0.3562f
C4308 a_8076_5863# VDD 0.34315f
C4309 a_1468_12568# a_1468_12135# 0.05841f
C4310 a_4068_14180# a_4156_14136# 0.30831f
C4311 a_15468_7431# a_15828_7528# 0.08707f
C4312 a_2276_4392# VDD 0.22866f
C4313 a_10204_7864# VDD 0.3462f
C4314 a_16724_9096# a_16612_7908# 0.02666f
C4315 a_932_10664# a_932_9476# 0.05841f
C4316 a_13564_17272# a_13676_16839# 0.02634f
C4317 a_15356_15704# dvo[0] 0.05238f
C4318 a_2276_11044# VDD 0.22866f
C4319 a_2276_12612# VDD 0.22866f
C4320 a_19388_17272# a_19500_16839# 0.02634f
C4321 a_11660_4295# a_12020_4392# 0.08663f
C4322 a_4964_7908# a_5052_7864# 0.30831f
C4323 a_4156_7431# VDD 0.35632f
C4324 a_10564_1636# VDD 0.22827f
C4325 a_18492_14136# VDD 0.33213f
C4326 a_13228_16839# VDD 0.34517f
C4327 a_12916_9476# VDD 0.2315f
C4328 a_20662_13352# ana_div_chain\[0\]_dff_notouch_.Q 0.75457f
C4329 a_8188_17272# a_8076_16839# 0.02634f
C4330 a_6196_2824# a_6308_1636# 0.02666f
C4331 a_16612_14180# a_16700_14136# 0.30831f
C4332 ana_div_chain\[1\]_inv_notouch_.ZN a_14932_11044# 0.11581f
C4333 a_21068_15271# VDD 0.35817f
C4334 a_2276_12612# a_1916_12568# 0.08707f
C4335 a_11324_1159# a_11236_1256# 0.30831f
C4336 a_18492_1592# VDD 0.35081f
C4337 a_1380_4772# a_1468_4728# 0.30831f
C4338 a_10340_13143# VDD 0.53746f
C4339 wire20.I dac_div_chain\[1\]_inv_notouch_.ZN 0.03268f
C4340 a_11996_3160# a_12108_2727# 0.02634f
C4341 a_20532_5960# VDD 0.24899f
C4342 input1.Z a_20620_7431# 0.05656f
C4343 a_22076_9432# VDD 0.37268f
C4344 a_12192_13053# a_12152_12637# 0.72261f
C4345 a_20420_18504# VDD 0.23118f
C4346 a_6844_3160# VDD 0.34473f
C4347 a_13140_2824# a_13252_1636# 0.02666f
C4348 a_11660_8999# a_12020_9096# 0.08663f
C4349 a_5948_14136# VDD 0.34473f
C4350 a_1380_15368# a_1380_14180# 0.05841f
C4351 a_12892_18407# a_13252_18504# 0.08717f
C4352 a_19836_3160# a_19948_2727# 0.02634f
C4353 a_6196_7528# a_6308_6340# 0.02666f
C4354 a_932_9096# VDD 0.24399f
C4355 a_7764_11911# dvo[2] 0.03426f
C4356 a_20644_3204# VDD 0.22854f
C4357 a_8996_13479# a_10971_13855# 0.04722f
C4358 a_16724_7528# VDD 0.22854f
C4359 a_8972_4295# dvo[3] 0.04613f
C4360 a_8076_5863# a_8436_5960# 0.08707f
C4361 a_1020_15704# VDD 0.33f
C4362 a_1468_15704# a_1468_15271# 0.05841f
C4363 a_15580_18407# VDD 0.36908f
C4364 ana_div_chain\[3\]_inv_notouch_.I a_16612_15748# 0.03701f
C4365 a_14372_15748# a_14460_15704# 0.30831f
C4366 a_3260_4728# VDD 0.33422f
C4367 a_11996_7864# a_12108_7431# 0.02634f
C4368 a_15044_4772# a_15132_4728# 0.30831f
C4369 a_1468_4728# a_1468_4295# 0.05841f
C4370 a_3620_11044# a_3708_11000# 0.30831f
C4371 a_13140_7528# a_13252_6340# 0.02666f
C4372 a_15020_2727# VDD 0.34315f
C4373 a_12352_11485# VDD 0.18911f
C4374 wire18.I VDD 1.0739f
C4375 a_19052_5863# a_18964_5960# 0.30831f
C4376 a_20755_808# a_21085_808# 0.54229f
C4377 a_15492_1256# VDD 0.232f
C4378 a_10900_16232# a_12108_15271# 0.05791f
C4379 a_932_13800# a_932_12612# 0.05841f
C4380 a_19412_15748# VDD 0.28025f
C4381 ana_div_chain\[2\]_dff_notouch_.CLK avo[3] 0.09821f
C4382 a_19836_7864# a_19948_7431# 0.02634f
C4383 a_17060_4772# VDD 0.22827f
C4384 a_17752_18101# avo[5] 0.52905f
C4385 a_13140_9096# VDD 0.22827f
C4386 a_19300_4772# a_18940_4728# 0.08717f
C4387 a_13272_13352# a_14320_13443# 0.03873f
C4388 a_21092_17316# VDD 0.23082f
C4389 a_11460_1636# a_11548_1592# 0.30831f
C4390 a_13280_11485# a_14124_10567# 0.03062f
C4391 a_15380_16936# VDD 0.23016f
C4392 a_7204_6340# VDD 0.22854f
C4393 a_3260_10567# VDD 0.33424f
C4394 ana_div_chain\[2\]_dff_notouch_.Q a_11478_11784# 0.76413f
C4395 a_14260_9476# a_14348_9432# 0.30831f
C4396 a_1020_15271# a_1380_15368# 0.08717f
C4397 a_13924_15047# VDD 2.23564f
C4398 ana_div_chain\[4\]_inv_notouch_.I avo[4] 0.22917f
C4399 a_11212_4295# VDD 0.35471f
C4400 a_15468_2727# a_15380_2824# 0.30831f
C4401 input1.Z a_20732_11000# 0.04635f
C4402 a_5748_2824# VDD 0.22842f
C4403 a_20732_11000# a_20620_10567# 0.02634f
C4404 a_19040_12683# a_19968_13053# 1.16478f
C4405 a_18628_13096# a_19596_13097# 0.22071f
C4406 input1.Z a_19968_13053# 0.03364f
C4407 a_13340_6296# VDD 0.34474f
C4408 a_5300_10664# VDD 0.22827f
C4409 a_3620_7908# VDD 0.25323f
C4410 a_19300_9476# a_18940_9432# 0.08717f
C4411 a_12108_15271# a_12020_15368# 0.30831f
C4412 a_11460_6340# a_11548_6296# 0.30831f
C4413 a_14392_12243# ana_div_chain\[1\]_inv_notouch_.ZN 0.31609f
C4414 a_4964_3204# a_4604_3160# 0.08707f
C4415 a_9868_10567# a_10228_10664# 0.0869f
C4416 a_15580_1592# a_15580_1159# 0.05841f
C4417 a_1916_12135# a_2276_12232# 0.08717f
C4418 a_7628_5863# VDD 0.34315f
C4419 a_11264_13443# VDD 0.77682f
C4420 a_11212_5863# avo[2] 0.06067f
C4421 input2.Z a_16612_12612# 0.03629f
C4422 a_4068_14180# a_3708_14136# 0.08707f
C4423 a_15468_7431# a_15380_7528# 0.30831f
C4424 a_1828_4392# VDD 0.2258f
C4425 a_9756_7864# VDD 0.34391f
C4426 wire12.I dvo[3] 0.03263f
C4427 input2.Z a_16364_10567# 0.04934f
C4428 ana_div_chain\[3\]_inv_notouch_.ZN dvo[1] 0.03836f
C4429 a_11256_16533# dac_div_chain\[4\]_dff_notouch_.CLK 0.20433f
C4430 a_7988_16936# a_8100_15748# 0.02666f
C4431 a_1828_11044# VDD 0.2258f
C4432 a_1828_12612# VDD 0.2258f
C4433 a_3708_7431# VDD 0.37719f
C4434 a_4964_7908# a_4604_7864# 0.08707f
C4435 a_17915_16991# a_18208_16579# 0.49886f
C4436 a_11660_4295# a_11572_4392# 0.30831f
C4437 a_15580_6296# a_15468_5863# 0.02634f
C4438 a_10116_1636# VDD 0.22827f
C4439 a_18044_14136# VDD 0.33004f
C4440 a_4156_11000# a_4156_10567# 0.05841f
C4441 a_5052_3160# a_4940_2727# 0.02634f
C4442 a_12468_9476# VDD 0.23044f
C4443 a_2724_12232# a_2724_11044# 0.05841f
C4444 a_20620_15271# VDD 0.36442f
C4445 VDD avo[0] 0.76735f
C4446 a_1828_12612# a_1916_12568# 0.30831f
C4447 a_18044_1592# VDD 0.35554f
C4448 a_21180_1592# a_21085_808# 0.02503f
C4449 a_1380_4772# a_1020_4728# 0.08707f
C4450 a_6644_10664# a_6756_9476# 0.02666f
C4451 a_9980_12568# VDD 0.3504f
C4452 a_10876_1159# a_11236_1256# 0.08717f
C4453 a_19860_5960# VDD 0.23913f
C4454 a_21628_9432# VDD 0.34473f
C4455 a_19972_18504# VDD 0.25357f
C4456 a_6396_3160# VDD 0.34473f
C4457 a_11660_8999# a_11572_9096# 0.30831f
C4458 a_5500_14136# VDD 0.34475f
C4459 a_10204_7864# avo[3] 0.04791f
C4460 a_19412_16936# a_19412_15748# 0.05841f
C4461 a_5052_7864# a_4940_7431# 0.02634f
C4462 a_12892_18407# a_12804_18504# 0.30831f
C4463 a_21964_8999# VDD 0.36442f
C4464 ana_div_chain\[0\]_dff_notouch_.D a_19040_12683# 0.28546f
C4465 a_19860_2824# a_19748_1636# 0.02666f
C4466 input1.Z ana_div_chain\[0\]_dff_notouch_.D 0.04024f
C4467 a_20196_3204# VDD 0.23094f
C4468 a_16276_7528# VDD 0.23094f
C4469 a_8996_13479# a_9964_13487# 0.22071f
C4470 a_8076_5863# a_7988_5960# 0.30831f
C4471 a_8100_15748# VDD 0.23473f
C4472 a_15132_18407# VDD 0.3407f
C4473 a_2812_4728# VDD 0.33144f
C4474 a_10564_1636# avo[3] 0.03141f
C4475 a_15044_4772# a_14684_4728# 0.08707f
C4476 a_3620_11044# a_3260_11000# 0.08717f
C4477 a_8100_1636# a_8188_1592# 0.30831f
C4478 a_2276_4392# a_2276_3204# 0.05841f
C4479 a_14572_2727# VDD 0.34315f
C4480 input2.Z a_16612_13800# 0.0509f
C4481 a_15044_1256# VDD 0.2258f
C4482 a_18604_5863# a_18964_5960# 0.08707f
C4483 a_18964_15748# VDD 0.23521f
C4484 a_21652_15748# a_21740_15704# 0.30831f
C4485 a_4156_2727# a_4068_2824# 0.30831f
C4486 a_16612_4772# VDD 0.24899f
C4487 a_18852_4772# a_18940_4728# 0.30831f
C4488 a_13272_13352# a_13876_13639# 0.49886f
C4489 a_12692_9096# VDD 0.24899f
C4490 a_20644_17316# VDD 0.23082f
C4491 a_19860_7528# a_19748_6340# 0.02666f
C4492 dvo[1] dvo[0] 0.21221f
C4493 a_14932_16936# VDD 0.22871f
C4494 a_11460_1636# a_11100_1592# 0.08707f
C4495 wire18.I a_14572_10567# 0.07326f
C4496 a_6756_6340# VDD 0.22854f
C4497 a_9332_4392# a_9220_3204# 0.02666f
C4498 a_2812_10567# VDD 0.33144f
C4499 a_14260_9476# a_13900_9432# 0.08717f
C4500 a_13228_15271# VDD 0.37028f
C4501 a_1020_15271# a_932_15368# 0.30831f
C4502 dac_div_chain\[2\]_load_slew11.Z dvo[2] 0.26476f
C4503 a_8100_6340# a_8188_6296# 0.30831f
C4504 a_10764_4295# VDD 0.3448f
C4505 a_15020_2727# a_15380_2824# 0.08707f
C4506 a_2276_9096# a_2276_7908# 0.05841f
C4507 a_5300_2824# VDD 0.22842f
C4508 a_18628_13096# a_19968_13053# 0.08109f
C4509 a_12892_6296# VDD 0.34477f
C4510 input1.Z a_19040_12683# 0.11151f
C4511 a_4852_10664# VDD 0.24963f
C4512 a_4156_7431# a_4068_7528# 0.30831f
C4513 a_16700_14136# a_16700_13703# 0.05841f
C4514 a_18852_9476# a_18940_9432# 0.30831f
C4515 a_3172_7908# VDD 0.23225f
C4516 a_11660_15271# a_12020_15368# 0.08663f
C4517 a_11460_6340# a_11100_6296# 0.08707f
C4518 a_6844_14136# a_6732_13703# 0.02634f
C4519 input1.Z a_20620_10567# 0.05656f
C4520 a_9332_9096# a_9220_7908# 0.02666f
C4521 a_4516_3204# a_4604_3160# 0.30831f
C4522 a_14432_11875# ana_div_chain\[1\]_inv_notouch_.ZN 0.14183f
C4523 a_9868_10567# a_9780_10664# 0.30831f
C4524 a_1020_12568# a_1020_12135# 0.05841f
C4525 a_1916_12135# a_1828_12232# 0.30831f
C4526 ana_div_chain\[1\]_dff_notouch_.CLK dvo[1] 0.0369f
C4527 a_10971_13855# VDD 0.42684f
C4528 a_7180_5863# VDD 0.34315f
C4529 a_3620_14180# a_3708_14136# 0.30831f
C4530 a_1380_4392# VDD 0.2258f
C4531 a_15020_7431# a_15380_7528# 0.08707f
C4532 dac_div_chain\[4\]_dff_notouch_.Q a_14012_17272# 0.04296f
C4533 a_9308_7864# VDD 0.34315f
C4534 a_11236_18504# a_10788_17316# 0.03829f
C4535 a_14336_15368# a_15899_15423# 0.41635f
C4536 ana_div_chain\[3\]_inv_notouch_.ZN a_14892_15055# 0.2111f
C4537 a_13116_17272# a_13228_16839# 0.02634f
C4538 a_10764_16839# dac_div_chain\[4\]_dff_notouch_.CLK 0.11091f
C4539 a_21876_12232# a_21988_11044# 0.02666f
C4540 a_21964_10567# a_21876_10664# 0.30831f
C4541 a_1380_11044# VDD 0.2258f
C4542 a_1380_12612# VDD 0.2258f
C4543 a_18940_17272# a_18208_16579# 0.03095f
C4544 dac_div_chain\[4\]_dff_notouch_.Q VDD 0.68418f
C4545 input2.Z a_16724_2824# 0.03114f
C4546 a_4516_7908# a_4604_7864# 0.30831f
C4547 a_3260_7431# VDD 0.33424f
C4548 a_11212_4295# a_11572_4392# 0.08707f
C4549 a_9668_1636# VDD 0.22827f
C4550 a_17596_14136# VDD 0.32752f
C4551 a_12020_9476# VDD 0.15458f
C4552 a_7740_17272# a_7628_16839# 0.02634f
C4553 a_5748_2824# a_5860_1636# 0.02666f
C4554 a_19724_15271# VDD 0.38701f
C4555 a_932_4392# a_932_3204# 0.05841f
C4556 a_1828_12612# a_1468_12568# 0.08707f
C4557 a_10876_1159# a_10788_1256# 0.30831f
C4558 a_17596_1592# VDD 0.33707f
C4559 a_11144_12971# VDD 0.78047f
C4560 a_19412_5960# VDD 0.28341f
C4561 a_11548_3160# a_11660_2727# 0.02634f
C4562 dac_div_chain\[0\]_inv_notouch_.ZN a_13272_13352# 0.04723f
C4563 a_21180_9432# VDD 0.34473f
C4564 a_19188_18504# VDD 0.26624f
C4565 a_12692_2824# a_12804_1636# 0.02666f
C4566 a_5948_3160# VDD 0.34473f
C4567 dac_div_chain\[3\]_inv_notouch_.I a_10900_16232# 0.06889f
C4568 a_11212_8999# a_11572_9096# 0.08707f
C4569 a_932_15368# a_932_14180# 0.05841f
C4570 a_5052_14136# VDD 0.34477f
C4571 a_12444_18407# a_12804_18504# 0.08717f
C4572 a_5748_7528# a_5860_6340# 0.02666f
C4573 a_19388_3160# a_19500_2727# 0.02634f
C4574 a_21516_8999# VDD 0.34315f
C4575 ana_div_chain\[0\]_dff_notouch_.D a_18628_13096# 0.13307f
C4576 a_19748_3204# VDD 0.2357f
C4577 a_932_9096# a_932_7908# 0.05841f
C4578 a_15828_7528# VDD 0.22827f
C4579 a_8996_13479# a_10336_13443# 0.08109f
C4580 a_7628_5863# a_7988_5960# 0.08707f
C4581 a_7652_15748# VDD 0.22854f
C4582 a_11548_7864# a_11660_7431# 0.02634f
C4583 a_14684_18407# VDD 0.3407f
C4584 a_1020_15704# a_1020_15271# 0.05841f
C4585 a_10116_1636# avo[3] 0.03132f
C4586 a_2364_4728# VDD 0.32958f
C4587 a_1020_4728# a_1020_4295# 0.05841f
C4588 a_14596_4772# a_14684_4728# 0.30831f
C4589 a_3172_11044# a_3260_11000# 0.30831f
C4590 a_8100_1636# a_7740_1592# 0.08663f
C4591 a_12692_7528# a_12804_6340# 0.02666f
C4592 a_14124_2727# VDD 0.34315f
C4593 a_18604_5863# a_18516_5960# 0.30831f
C4594 a_18516_15748# VDD 0.23648f
C4595 a_14596_1256# VDD 0.2258f
C4596 a_20060_1159# a_19972_1256# 0.30831f
C4597 VDD uio_oe[3] 0.31453f
C4598 a_21652_15748# a_21292_15704# 0.08674f
C4599 a_19388_7864# a_19500_7431# 0.02634f
C4600 a_3708_2727# a_4068_2824# 0.08717f
C4601 a_16028_4728# VDD 0.37312f
C4602 a_12020_9096# VDD 0.24089f
C4603 a_18852_4772# a_18492_4728# 0.08717f
C4604 a_20196_17316# VDD 0.23082f
C4605 a_14892_15055# dvo[0] 0.04178f
C4606 a_14484_16936# VDD 0.22882f
C4607 a_11012_1636# a_11100_1592# 0.30831f
C4608 wire18.I a_14124_10567# 0.0349f
C4609 a_6308_6340# VDD 0.22854f
C4610 a_2364_10567# VDD 0.32958f
C4611 a_12780_15271# VDD 0.34625f
C4612 a_13812_9476# a_13900_9432# 0.30831f
C4613 a_21740_13703# a_21652_13800# 0.30831f
C4614 a_10316_4295# VDD 0.34474f
C4615 a_15020_2727# a_14932_2824# 0.30831f
C4616 a_8100_6340# a_7740_6296# 0.08663f
C4617 a_18628_13096# a_19040_12683# 0.72307f
C4618 a_4852_2824# VDD 0.24978f
C4619 a_12444_6296# VDD 0.35949f
C4620 input1.Z a_18628_13096# 0.55181f
C4621 a_4068_10664# VDD 0.24448f
C4622 a_3708_7431# a_4068_7528# 0.08717f
C4623 a_2724_7908# VDD 0.23014f
C4624 a_18852_9476# a_18492_9432# 0.08717f
C4625 a_11660_15271# a_11572_15368# 0.30831f
C4626 a_21709_808# ana_vco_in 0.4827f
C4627 a_11012_6340# a_11100_6296# 0.30831f
C4628 a_4516_3204# a_4156_3160# 0.08707f
C4629 a_8772_9476# dvo[3] 0.04625f
C4630 a_15132_1592# a_15132_1159# 0.05841f
C4631 a_9420_10567# a_9780_10664# 0.0869f
C4632 a_1468_12135# a_1828_12232# 0.08717f
C4633 a_6732_5863# VDD 0.34315f
C4634 a_9964_13487# VDD 0.40707f
C4635 a_3620_14180# a_3260_14136# 0.08707f
C4636 a_15020_7431# a_14932_7528# 0.30831f
C4637 dac_div_chain\[4\]_dff_notouch_.Q a_13564_17272# 0.0336f
C4638 a_8860_7864# VDD 0.34777f
C4639 a_8188_6296# a_8076_5863# 0.02634f
C4640 a_10764_16839# a_10676_16936# 0.30831f
C4641 a_14336_15368# a_14892_15055# 0.83991f
C4642 a_7540_16936# a_7652_15748# 0.02666f
C4643 a_21516_10567# a_21876_10664# 0.0869f
C4644 a_932_11044# VDD 0.24399f
C4645 a_932_12612# VDD 0.24399f
C4646 a_12038_17744# VDD 0.82525f
C4647 ana_div_chain\[3\]_inv_notouch_.I a_16192_15011# 0.28803f
C4648 a_11212_4295# a_11124_4392# 0.30831f
C4649 a_4516_7908# a_4156_7864# 0.08707f
C4650 a_2812_7431# VDD 0.33144f
C4651 a_9220_1636# VDD 0.22827f
C4652 a_15132_6296# a_15020_5863# 0.02634f
C4653 a_17148_14136# VDD 0.32605f
C4654 a_3708_11000# a_3708_10567# 0.05841f
C4655 a_11012_9476# VDD 0.23861f
C4656 a_2276_12232# a_2276_11044# 0.05841f
C4657 a_19276_15271# VDD 0.41672f
C4658 dac_div_chain\[4\]_inv_notouch_.I dvo[5] 0.06456f
C4659 a_1380_12612# a_1468_12568# 0.30831f
C4660 a_9892_12612# VDD 0.14403f
C4661 a_6196_10664# a_6308_9476# 0.02666f
C4662 a_10428_1159# a_10788_1256# 0.08717f
C4663 a_17148_1592# VDD 0.34693f
C4664 wire20.I a_12152_12637# 0.05254f
C4665 a_11748_12568# a_12152_12637# 0.41635f
C4666 a_21988_3204# a_22076_3160# 0.30831f
C4667 a_18964_5960# VDD 0.23661f
C4668 a_14708_12612# a_12192_13053# 0.04428f
C4669 a_20732_9432# VDD 0.34474f
C4670 dac_div_chain\[2\]_load_slew11.Z a_7988_10664# 0.04334f
C4671 a_18740_18504# VDD 0.22874f
C4672 a_5500_3160# VDD 0.34475f
C4673 a_11212_8999# a_11124_9096# 0.30831f
C4674 a_4604_14136# VDD 0.35949f
C4675 a_12444_18407# a_12356_18504# 0.30831f
C4676 a_21068_8999# VDD 0.34315f
C4677 a_19300_3204# VDD 0.28063f
C4678 a_19412_2824# a_19300_1636# 0.02666f
C4679 a_15380_7528# VDD 0.22827f
C4680 a_8996_13479# a_9408_13800# 0.72261f
C4681 a_7204_15748# VDD 0.22854f
C4682 a_7628_5863# a_7540_5960# 0.30831f
C4683 input2.Z a_16612_9476# 0.05125f
C4684 a_21988_7908# a_22076_7864# 0.30831f
C4685 a_14236_18407# VDD 0.3407f
C4686 a_1916_4728# VDD 0.32626f
C4687 a_14596_4772# a_14236_4728# 0.08707f
C4688 a_3172_11044# a_2812_11000# 0.08717f
C4689 a_7652_1636# a_7740_1592# 0.30831f
C4690 a_1828_4392# a_1828_3204# 0.05841f
C4691 a_13676_2727# VDD 0.34315f
C4692 a_18156_5863# a_18516_5960# 0.08707f
C4693 a_14148_1256# VDD 0.2258f
C4694 a_18068_15748# VDD 0.2301f
C4695 a_21204_15748# a_21292_15704# 0.30831f
C4696 a_3708_2727# a_3620_2824# 0.30831f
C4697 a_15580_4728# VDD 0.34473f
C4698 a_11572_9096# VDD 0.29173f
C4699 a_18404_4772# a_18492_4728# 0.30831f
C4700 a_19748_17316# VDD 0.23822f
C4701 a_14036_16936# VDD 0.23014f
C4702 a_11012_1636# a_10652_1592# 0.08707f
C4703 a_19412_7528# a_19300_6340# 0.02666f
C4704 a_15264_15011# dvo[0] 0.04098f
C4705 wire18.I a_13676_10567# 0.02694f
C4706 a_8884_4392# a_8772_3204# 0.02666f
C4707 a_5860_6340# VDD 0.22854f
C4708 a_1916_10567# VDD 0.32626f
C4709 a_13812_9476# a_13452_9432# 0.08717f
C4710 a_12108_15271# VDD 0.35799f
C4711 a_14572_2727# a_14932_2824# 0.08707f
C4712 a_7652_6340# a_7740_6296# 0.30831f
C4713 a_9868_4295# VDD 0.34473f
C4714 a_1828_9096# a_1828_7908# 0.05841f
C4715 uio_oe[7] uio_oe[6] 0.09374f
C4716 a_19836_11000# a_19948_10567# 0.02634f
C4717 a_4068_2824# VDD 0.24448f
C4718 a_11996_6296# VDD 0.34951f
C4719 a_3620_10664# VDD 0.25323f
C4720 a_21964_15271# a_21876_15368# 0.30831f
C4721 a_3708_7431# a_3620_7528# 0.30831f
C4722 a_2276_7908# VDD 0.22866f
C4723 a_18404_9476# a_18492_9432# 0.30831f
C4724 a_11212_15271# a_11572_15368# 0.08707f
C4725 a_21085_808# ana_vco_in 0.0692f
C4726 a_11012_6340# a_10652_6296# 0.08707f
C4727 a_6396_14136# a_6284_13703# 0.02634f
C4728 a_8884_9096# a_8772_7908# 0.02666f
C4729 a_4068_3204# a_4156_3160# 0.30831f
C4730 a_9420_10567# a_9332_10664# 0.30831f
C4731 a_1468_12135# a_1380_12232# 0.30831f
C4732 input2.Z VDD 2.22708f
C4733 a_6284_5863# VDD 0.34315f
C4734 a_10336_13443# VDD 0.19321f
C4735 a_3172_14180# a_3260_14136# 0.30831f
C4736 a_14572_7431# a_14932_7528# 0.08707f
C4737 input1.Z a_20532_2824# 0.04429f
C4738 dac_div_chain\[4\]_dff_notouch_.Q a_13116_17272# 0.03454f
C4739 a_15940_7908# VDD 0.23543f
C4740 a_10316_16839# a_10676_16936# 0.08674f
C4741 a_14336_15368# a_15264_15011# 1.16478f
C4742 a_21428_12232# a_21540_11044# 0.02666f
C4743 a_21516_10567# a_21428_10664# 0.30831f
C4744 ana_div_chain\[3\]_inv_notouch_.I dvo[1] 0.10663f
C4745 a_21652_13800# VDD 0.14478f
C4746 ana_div_chain\[3\]_inv_notouch_.I a_15899_15423# 0.03567f
C4747 a_10788_17316# VDD 0.90804f
C4748 a_932_3204# VDD 0.24399f
C4749 a_4068_7908# a_4156_7864# 0.30831f
C4750 a_2364_7431# VDD 0.32958f
C4751 a_10764_4295# a_11124_4392# 0.08707f
C4752 a_10316_4295# avo[3] 0.05714f
C4753 a_8772_1636# VDD 0.24899f
C4754 a_16700_14136# VDD 0.33226f
C4755 a_4156_3160# a_4156_2727# 0.05841f
C4756 ana_div_chain\[4\]_inv_notouch_.I a_16612_17316# 0.05865f
C4757 a_7292_17272# a_7180_16839# 0.02634f
C4758 a_10564_9476# VDD 0.23217f
C4759 a_15828_5960# a_15940_4772# 0.02666f
C4760 a_5300_2824# a_5412_1636# 0.02666f
C4761 wire18.I ana_div_chain\[1\]_inv_notouch_.ZN 0.48202f
C4762 a_18828_15271# VDD 0.36654f
C4763 a_21964_4295# a_21876_4392# 0.30831f
C4764 a_11796_16577# dvo[5] 0.53081f
C4765 a_1380_12612# a_1020_12568# 0.08707f
C4766 a_16700_1592# VDD 0.35692f
C4767 a_10428_1159# a_10340_1256# 0.30831f
C4768 a_18516_5960# VDD 0.23398f
C4769 wire20.I a_12192_13053# 0.02944f
C4770 a_11100_3160# a_11212_2727# 0.02634f
C4771 a_21988_3204# a_21628_3160# 0.08663f
C4772 a_11748_12568# a_12192_13053# 0.04722f
C4773 a_20284_9432# VDD 0.35948f
C4774 a_18292_18504# VDD 0.14245f
C4775 a_10788_18504# dac_div_chain\[3\]_inv_notouch_.I 0.03733f
C4776 a_5052_3160# VDD 0.34477f
C4777 a_10764_8999# a_11124_9096# 0.08707f
C4778 input1.Z a_20644_9476# 0.05679f
C4779 a_4156_14136# VDD 0.33493f
C4780 a_8884_9096# dvo[3] 0.05679f
C4781 a_4156_7864# a_4156_7431# 0.05841f
C4782 a_21988_17316# a_22076_17272# 0.30831f
C4783 a_18940_3160# a_19052_2727# 0.02634f
C4784 a_5300_7528# a_5412_6340# 0.02666f
C4785 a_20620_8999# VDD 0.34779f
C4786 a_18852_3204# VDD 0.2354f
C4787 a_21964_8999# a_21876_9096# 0.30831f
C4788 a_14932_7528# VDD 0.22827f
C4789 a_7180_5863# a_7540_5960# 0.08707f
C4790 a_6756_15748# VDD 0.22854f
C4791 a_13788_18407# VDD 0.3407f
C4792 a_11100_7864# a_11212_7431# 0.02634f
C4793 a_21988_7908# a_21628_7864# 0.08663f
C4794 a_1468_4728# VDD 0.32605f
C4795 a_2724_11044# a_2812_11000# 0.30831f
C4796 a_21876_10664# a_21988_9476# 0.02666f
C4797 a_14148_4772# a_14236_4728# 0.30831f
C4798 dac_div_chain\[4\]_dff_notouch_.CLK dac_div_chain\[4\]_dff_notouch_.D 0.0264f
C4799 a_15828_11044# a_15916_11000# 0.30831f
C4800 a_7652_1636# a_7292_1592# 0.08707f
C4801 dac_div_chain\[3\]_inv_notouch_.I a_11124_15368# 0.03766f
C4802 a_13228_2727# VDD 0.34317f
C4803 dac_div_chain\[1\]_inv_notouch_.I VDD 1.23256f
C4804 a_19276_1159# a_19188_1256# 0.30831f
C4805 a_17620_15748# VDD 0.21454f
C4806 a_13700_1256# VDD 0.2258f
C4807 a_18156_5863# a_18068_5960# 0.30831f
C4808 a_15132_4728# VDD 0.34473f
C4809 a_21204_15748# a_20844_15704# 0.08674f
C4810 a_3260_2727# a_3620_2824# 0.08717f
C4811 a_18940_7864# a_19052_7431# 0.02634f
C4812 input2.Z a_14280_13811# 0.05876f
C4813 a_18404_4772# a_18044_4728# 0.08717f
C4814 a_8963_18100# uio_oe[1] 0.04649f
C4815 a_11124_9096# VDD 0.23478f
C4816 a_19300_17316# VDD 0.28111f
C4817 a_10564_1636# a_10652_1592# 0.30831f
C4818 a_13588_16936# VDD 0.22995f
C4819 a_5412_6340# VDD 0.22854f
C4820 a_1468_10567# VDD 0.32605f
C4821 a_11660_15271# VDD 0.39803f
C4822 a_13364_9476# a_13452_9432# 0.30831f
C4823 a_7652_6340# a_7292_6296# 0.08707f
C4824 a_9420_4295# VDD 0.34473f
C4825 a_14572_2727# a_14484_2824# 0.30831f
C4826 a_3620_2824# VDD 0.25323f
C4827 a_8996_13479# wire12.I 0.52282f
C4828 a_11548_6296# VDD 0.40851f
C4829 a_3172_10664# VDD 0.23225f
C4830 a_3260_7431# a_3620_7528# 0.08717f
C4831 a_21516_15271# a_21876_15368# 0.0869f
C4832 a_18404_9476# a_18044_9432# 0.08717f
C4833 a_1828_7908# VDD 0.2258f
C4834 a_11212_15271# a_11124_15368# 0.30831f
C4835 a_10564_6340# a_10652_6296# 0.30831f
C4836 a_4068_3204# a_3708_3160# 0.08707f
C4837 a_15940_16615# a_18208_16579# 0.03873f
C4838 a_1020_12135# a_1380_12232# 0.08717f
C4839 a_8792_10261# a_9332_10664# 0.19392f
C4840 a_15398_14516# VDD 0.66495f
C4841 a_14684_1592# a_14684_1159# 0.05841f
C4842 a_5836_5863# VDD 0.34315f
C4843 a_9408_13800# VDD 1.12737f
C4844 a_3172_14180# a_2812_14136# 0.08707f
C4845 a_14572_7431# a_14484_7528# 0.30831f
C4846 a_15492_7908# VDD 0.22869f
C4847 a_7740_6296# a_7628_5863# 0.02634f
C4848 a_10316_16839# a_10228_16936# 0.30831f
C4849 a_7092_16936# a_7204_15748# 0.02666f
C4850 a_21068_10567# a_21428_10664# 0.0869f
C4851 a_21876_12232# VDD 0.23402f
C4852 ana_div_chain\[3\]_inv_notouch_.I a_14892_15055# 0.03055f
C4853 a_21876_4392# VDD 0.23402f
C4854 a_17280_16579# a_16908_16623# 0.10745f
C4855 a_10764_4295# a_10676_4392# 0.30831f
C4856 a_4068_7908# a_3708_7864# 0.08707f
C4857 a_1916_7431# VDD 0.32626f
C4858 a_14684_6296# a_14572_5863# 0.02634f
C4859 a_8188_1592# VDD 0.38747f
C4860 a_21764_14180# VDD 0.23398f
C4861 a_3260_11000# a_3260_10567# 0.05841f
C4862 a_17060_18504# a_16612_17316# 0.03829f
C4863 a_10116_9476# VDD 0.23212f
C4864 a_1828_12232# a_1828_11044# 0.05841f
C4865 a_18380_15271# VDD 0.36406f
C4866 a_21516_4295# a_21876_4392# 0.0869f
C4867 a_932_12612# a_1020_12568# 0.30831f
C4868 a_1020_5863# a_932_5960# 0.30831f
C4869 a_11772_18407# dvo[5] 0.04984f
C4870 a_9980_1159# a_10340_1256# 0.08717f
C4871 a_5748_10664# a_5860_9476# 0.02666f
C4872 a_21988_1636# VDD 0.23471f
C4873 a_21540_3204# a_21628_3160# 0.30831f
C4874 a_18068_5960# VDD 0.23212f
C4875 a_12668_14136# a_12780_13703# 0.02634f
C4876 a_19836_9432# VDD 0.34748f
C4877 a_12020_2824# a_11908_1636# 0.02666f
C4878 a_4604_3160# VDD 0.35949f
C4879 a_10764_8999# a_10676_9096# 0.30831f
C4880 a_3708_14136# VDD 0.37719f
C4881 a_11772_18407# a_11684_18504# 0.30831f
C4882 a_21988_17316# a_21628_17272# 0.08717f
C4883 a_932_1256# VDD 0.24399f
C4884 a_19948_8999# VDD 0.37418f
C4885 dac_div_chain\[3\]_inv_notouch_.I VDD 1.56966f
C4886 a_18404_3204# VDD 0.23318f
C4887 a_18964_2824# a_18852_1636# 0.02666f
C4888 a_21516_8999# a_21876_9096# 0.0869f
C4889 a_14484_7528# VDD 0.22827f
C4890 a_6308_15748# VDD 0.22854f
C4891 a_7180_5863# a_7092_5960# 0.30831f
C4892 a_13340_18407# VDD 0.3407f
C4893 a_1020_4728# VDD 0.33f
C4894 a_21540_7908# a_21628_7864# 0.30831f
C4895 ana_div_chain\[4\]_inv_notouch_.I ana_div_chain\[3\]_inv_notouch_.I 0.09529f
C4896 a_14148_4772# a_13788_4728# 0.08707f
C4897 a_2724_11044# a_2364_11000# 0.08717f
C4898 dac_div_chain\[4\]_dff_notouch_.Q dvo[4] 0.09673f
C4899 a_8860_6296# dvo[3] 0.05656f
C4900 a_12020_7528# a_11908_6340# 0.02666f
C4901 a_15828_11044# a_15468_11000# 0.08663f
C4902 a_7204_1636# a_7292_1592# 0.30831f
C4903 a_10564_9476# avo[3] 0.02803f
C4904 a_1380_4392# a_1380_3204# 0.05841f
C4905 a_12780_2727# VDD 0.3478f
C4906 a_8902_13040# VDD 0.78039f
C4907 a_13384_11784# VDD 0.7286f
C4908 a_18828_1159# a_19188_1256# 0.08663f
C4909 a_17708_5863# a_18068_5960# 0.08707f
C4910 a_13252_1256# VDD 0.2258f
C4911 a_10204_15704# a_10316_15271# 0.02634f
C4912 a_20756_15748# a_20844_15704# 0.30831f
C4913 a_16612_15748# VDD 0.24927f
C4914 a_3260_2727# a_3172_2824# 0.30831f
C4915 a_14684_4728# VDD 0.34473f
C4916 input2.Z a_14320_13443# 0.62685f
C4917 a_17956_4772# a_18044_4728# 0.30831f
C4918 a_10676_9096# VDD 0.23366f
C4919 a_10340_11575# ana_div_chain\[2\]_inv_notouch_.I 0.2264f
C4920 a_18852_17316# VDD 0.147f
C4921 a_18964_7528# a_18852_6340# 0.02666f
C4922 a_10564_1636# a_10204_1592# 0.08707f
C4923 a_13140_16936# VDD 0.21398f
C4924 dac_div_chain\[1\]_dff_notouch_.CLK a_13272_13352# 0.03863f
C4925 a_4964_6340# VDD 0.22854f
C4926 a_1020_10567# VDD 0.33f
C4927 a_11212_15271# VDD 0.35917f
C4928 a_13364_9476# a_13004_9432# 0.08717f
C4929 a_8972_4295# VDD 0.34473f
C4930 a_14124_2727# a_14484_2824# 0.08707f
C4931 a_7204_6340# a_7292_6296# 0.30831f
C4932 a_1380_9096# a_1380_7908# 0.05841f
C4933 a_19388_11000# a_19500_10567# 0.02634f
C4934 a_3172_2824# VDD 0.23225f
C4935 a_11100_6296# VDD 0.35005f
C4936 a_2724_10664# VDD 0.23014f
C4937 a_21516_15271# a_21428_15368# 0.30831f
C4938 a_3260_7431# a_3172_7528# 0.30831f
C4939 dac_div_chain\[4\]_dff_notouch_.D a_11868_16233# 0.25208f
C4940 a_1380_7908# VDD 0.2258f
C4941 a_17956_9476# a_18044_9432# 0.30831f
C4942 a_10764_15271# a_11124_15368# 0.08707f
C4943 a_10564_6340# a_10204_6296# 0.08707f
C4944 a_5948_14136# a_5836_13703# 0.02634f
C4945 a_3620_3204# a_3708_3160# 0.30831f
C4946 a_15940_16615# a_17915_16991# 0.04722f
C4947 a_1020_12135# a_932_12232# 0.30831f
C4948 a_5388_5863# VDD 0.34317f
C4949 a_14124_7431# a_14484_7528# 0.08707f
C4950 a_2724_14180# a_2812_14136# 0.30831f
C4951 a_15044_7908# VDD 0.22869f
C4952 a_11100_7864# avo[2] 0.04791f
C4953 a_9868_16839# a_10228_16936# 0.08674f
C4954 a_20980_12232# a_21092_11044# 0.02666f
C4955 a_21068_10567# a_20980_10664# 0.30831f
C4956 a_21428_12232# VDD 0.22827f
C4957 a_21428_4392# VDD 0.22827f
C4958 ana_div_chain\[1\]_dff_notouch_.CLK ana_div_chain\[0\]_dff_notouch_.D 0.45882f
C4959 a_3620_7908# a_3708_7864# 0.30831f
C4960 a_1468_7431# VDD 0.32605f
C4961 a_10316_4295# a_10676_4392# 0.08707f
C4962 input2.Z a_16724_10664# 0.03114f
C4963 a_7740_1592# VDD 0.35817f
C4964 a_21316_14180# VDD 0.17697f
C4965 a_3708_3160# a_3708_2727# 0.05841f
C4966 a_15380_5960# a_15492_4772# 0.02666f
C4967 a_6844_17272# a_6732_16839# 0.02634f
C4968 a_9668_9476# VDD 0.22901f
C4969 a_4852_2824# a_4964_1636# 0.02666f
C4970 a_17932_15271# VDD 0.36178f
C4971 a_21516_4295# a_21428_4392# 0.30831f
C4972 a_9980_1159# a_9892_1256# 0.30831f
C4973 wire12.I VDD 0.81577f
C4974 a_21540_1636# VDD 0.22854f
C4975 a_14728_14640# dvo[1] 0.55434f
C4976 a_21540_3204# a_21180_3160# 0.0869f
C4977 a_10652_3160# a_10764_2727# 0.02634f
C4978 wire20.I a_14708_12612# 0.76254f
C4979 a_17620_5960# VDD 0.22999f
C4980 VDD uio_oe[6] 0.31313f
C4981 a_19388_9432# VDD 0.40424f
C4982 a_4156_3160# VDD 0.33493f
C4983 a_10316_8999# a_10676_9096# 0.08707f
C4984 a_3260_14136# VDD 0.33422f
C4985 a_3708_7864# a_3708_7431# 0.05841f
C4986 a_11324_18407# a_11684_18504# 0.08663f
C4987 a_21540_17316# a_21628_17272# 0.30831f
C4988 a_16611_808# VDD 0.33047f
C4989 ana_vco_in VSS 1.18337f
C4990 dac_vco_in VSS 1.57821f
C4991 dvo[3] VSS 5.03502f
C4992 avo[3] VSS 4.81405f
C4993 avo[2] VSS 4.93512f
C4994 dvo[2] VSS 5.02601f
C4995 avo[1] VSS 4.71286f
C4996 avo[0] VSS 2.65882f
C4997 dvo[0] VSS 2.45486f
C4998 dvo[1] VSS 3.34626f
C4999 avo[4] VSS 2.70995f
C5000 dvo[5] VSS 2.35079f
C5001 dvo[4] VSS 3.35058f
C5002 uio_oe[0] VSS 0.69139f
C5003 uio_oe[1] VSS 0.654f
C5004 uio_oe[2] VSS 0.65919f
C5005 uio_oe[3] VSS 0.66428f
C5006 uio_oe[4] VSS 0.81395f
C5007 uio_oe[5] VSS 0.67144f
C5008 uio_oe[6] VSS 0.65827f
C5009 uio_oe[7] VSS 0.95433f
C5010 avo[5] VSS 2.21405f
C5011 VDD VSS 0.79355p
C5012 a_21709_808# VSS 0.58427f
C5013 a_21085_808# VSS 0.55832f
C5014 a_19972_1256# VSS 0.43664f
C5015 a_19188_1256# VSS 0.36623f
C5016 a_18740_1256# VSS 0.35938f
C5017 a_18292_1256# VSS 0.36094f
C5018 a_20755_808# VSS 0.52272f
C5019 a_20060_1159# VSS 0.19321f
C5020 a_19276_1159# VSS 0.15535f
C5021 a_18828_1159# VSS 0.17101f
C5022 a_18380_1159# VSS 0.17017f
C5023 a_17565_808# VSS 0.56265f
C5024 a_16941_808# VSS 0.55223f
C5025 a_15492_1256# VSS 0.35606f
C5026 a_15044_1256# VSS 0.35015f
C5027 a_14596_1256# VSS 0.35015f
C5028 a_14148_1256# VSS 0.35015f
C5029 a_13700_1256# VSS 0.35322f
C5030 a_13252_1256# VSS 0.35489f
C5031 a_12804_1256# VSS 0.35747f
C5032 a_12356_1256# VSS 0.40465f
C5033 a_11684_1256# VSS 0.35666f
C5034 a_11236_1256# VSS 0.3502f
C5035 a_10788_1256# VSS 0.35017f
C5036 a_10340_1256# VSS 0.35015f
C5037 a_9892_1256# VSS 0.35015f
C5038 a_9444_1256# VSS 0.35015f
C5039 a_8996_1256# VSS 0.35015f
C5040 a_8548_1256# VSS 0.36086f
C5041 a_7876_1256# VSS 0.35398f
C5042 a_7428_1256# VSS 0.35015f
C5043 a_6980_1256# VSS 0.35015f
C5044 a_6532_1256# VSS 0.35015f
C5045 a_6084_1256# VSS 0.35268f
C5046 a_5636_1256# VSS 0.35421f
C5047 a_5188_1256# VSS 0.35635f
C5048 a_4740_1256# VSS 0.37402f
C5049 a_4068_1256# VSS 0.3617f
C5050 a_3620_1256# VSS 0.35022f
C5051 a_3172_1256# VSS 0.35018f
C5052 a_2724_1256# VSS 0.35016f
C5053 a_2276_1256# VSS 0.35015f
C5054 a_1828_1256# VSS 0.35015f
C5055 a_1380_1256# VSS 0.35015f
C5056 a_932_1256# VSS 0.37674f
C5057 a_16611_808# VSS 0.51842f
C5058 a_15580_1159# VSS 0.17133f
C5059 a_15132_1159# VSS 0.16198f
C5060 a_14684_1159# VSS 0.16198f
C5061 a_14236_1159# VSS 0.16198f
C5062 a_13788_1159# VSS 0.16509f
C5063 a_13340_1159# VSS 0.16666f
C5064 a_12892_1159# VSS 0.16887f
C5065 a_12444_1159# VSS 0.18917f
C5066 a_11772_1159# VSS 0.17873f
C5067 a_11324_1159# VSS 0.16688f
C5068 a_10876_1159# VSS 0.16688f
C5069 a_10428_1159# VSS 0.16688f
C5070 a_9980_1159# VSS 0.16688f
C5071 a_9532_1159# VSS 0.16688f
C5072 a_9084_1159# VSS 0.16688f
C5073 a_8636_1159# VSS 0.17068f
C5074 a_7964_1159# VSS 0.17171f
C5075 a_7516_1159# VSS 0.16696f
C5076 a_7068_1159# VSS 0.16696f
C5077 a_6620_1159# VSS 0.16696f
C5078 a_6172_1159# VSS 0.16888f
C5079 a_5724_1159# VSS 0.17101f
C5080 a_5276_1159# VSS 0.17303f
C5081 a_4828_1159# VSS 0.17997f
C5082 a_4156_1159# VSS 0.17943f
C5083 a_3708_1159# VSS 0.16198f
C5084 a_3260_1159# VSS 0.16198f
C5085 a_2812_1159# VSS 0.16198f
C5086 a_2364_1159# VSS 0.16198f
C5087 a_1916_1159# VSS 0.16198f
C5088 a_1468_1159# VSS 0.16198f
C5089 a_1020_1159# VSS 0.17212f
C5090 a_22076_1592# VSS 0.18887f
C5091 a_21628_1592# VSS 0.17281f
C5092 a_21180_1592# VSS 0.16952f
C5093 a_20732_1592# VSS 0.17274f
C5094 a_20284_1592# VSS 0.18257f
C5095 a_19836_1592# VSS 0.20915f
C5096 a_19388_1592# VSS 0.16681f
C5097 a_18940_1592# VSS 0.16574f
C5098 a_18492_1592# VSS 0.16574f
C5099 a_18044_1592# VSS 0.16758f
C5100 a_17596_1592# VSS 0.16198f
C5101 a_17148_1592# VSS 0.16597f
C5102 a_16700_1592# VSS 0.17142f
C5103 a_21988_1636# VSS 0.34944f
C5104 a_21540_1636# VSS 0.33789f
C5105 a_21092_1636# VSS 0.33943f
C5106 a_20644_1636# VSS 0.34068f
C5107 a_20196_1636# VSS 0.38125f
C5108 a_19748_1636# VSS 0.3465f
C5109 a_19300_1636# VSS 0.331f
C5110 a_18852_1636# VSS 0.33095f
C5111 a_18404_1636# VSS 0.33093f
C5112 a_17956_1636# VSS 0.33091f
C5113 a_17508_1636# VSS 0.33091f
C5114 a_17060_1636# VSS 0.33091f
C5115 a_16612_1636# VSS 0.34162f
C5116 a_16028_1592# VSS 0.17497f
C5117 a_15580_1592# VSS 0.16662f
C5118 a_15132_1592# VSS 0.16314f
C5119 a_14684_1592# VSS 0.16314f
C5120 a_14236_1592# VSS 0.16314f
C5121 a_13788_1592# VSS 0.16625f
C5122 a_13340_1592# VSS 0.16782f
C5123 a_12892_1592# VSS 0.17003f
C5124 a_12444_1592# VSS 0.18648f
C5125 a_11996_1592# VSS 0.1947f
C5126 a_11548_1592# VSS 0.17004f
C5127 a_11100_1592# VSS 0.17f
C5128 a_10652_1592# VSS 0.17f
C5129 a_10204_1592# VSS 0.17f
C5130 a_9756_1592# VSS 0.17f
C5131 a_9308_1592# VSS 0.17f
C5132 a_8860_1592# VSS 0.1735f
C5133 a_15940_1636# VSS 0.34558f
C5134 a_15492_1636# VSS 0.33168f
C5135 a_15044_1636# VSS 0.33168f
C5136 a_14596_1636# VSS 0.33168f
C5137 a_14148_1636# VSS 0.33168f
C5138 a_13700_1636# VSS 0.33475f
C5139 a_13252_1636# VSS 0.33642f
C5140 a_12804_1636# VSS 0.339f
C5141 a_12356_1636# VSS 0.39062f
C5142 a_11908_1636# VSS 0.3418f
C5143 a_11460_1636# VSS 0.333f
C5144 a_11012_1636# VSS 0.33295f
C5145 a_10564_1636# VSS 0.33294f
C5146 a_10116_1636# VSS 0.33292f
C5147 a_9668_1636# VSS 0.33292f
C5148 a_9220_1636# VSS 0.33292f
C5149 a_8772_1636# VSS 0.34353f
C5150 a_8188_1592# VSS 0.17497f
C5151 a_7740_1592# VSS 0.17348f
C5152 a_7292_1592# VSS 0.17f
C5153 a_6844_1592# VSS 0.17f
C5154 a_6396_1592# VSS 0.17f
C5155 a_5948_1592# VSS 0.1733f
C5156 a_5500_1592# VSS 0.17498f
C5157 a_5052_1592# VSS 0.17723f
C5158 a_4604_1592# VSS 0.20831f
C5159 a_4156_1592# VSS 0.17427f
C5160 a_3708_1592# VSS 0.16314f
C5161 a_3260_1592# VSS 0.16314f
C5162 a_2812_1592# VSS 0.16314f
C5163 a_2364_1592# VSS 0.16314f
C5164 a_1916_1592# VSS 0.16314f
C5165 a_1468_1592# VSS 0.16314f
C5166 a_1020_1592# VSS 0.17306f
C5167 a_8100_1636# VSS 0.34558f
C5168 a_7652_1636# VSS 0.33168f
C5169 a_7204_1636# VSS 0.33168f
C5170 a_6756_1636# VSS 0.33168f
C5171 a_6308_1636# VSS 0.33219f
C5172 a_5860_1636# VSS 0.33495f
C5173 a_5412_1636# VSS 0.33673f
C5174 a_4964_1636# VSS 0.33949f
C5175 a_4516_1636# VSS 0.40303f
C5176 a_4068_1636# VSS 0.32255f
C5177 a_3620_1636# VSS 0.31538f
C5178 a_3172_1636# VSS 0.31534f
C5179 a_2724_1636# VSS 0.31532f
C5180 a_2276_1636# VSS 0.31531f
C5181 a_1828_1636# VSS 0.31531f
C5182 a_1380_1636# VSS 0.31531f
C5183 a_932_1636# VSS 0.34181f
C5184 a_21876_2824# VSS 0.34459f
C5185 a_21428_2824# VSS 0.34082f
C5186 a_20980_2824# VSS 0.34141f
C5187 a_20532_2824# VSS 0.35492f
C5188 a_19860_2824# VSS 0.38352f
C5189 a_19412_2824# VSS 0.3343f
C5190 a_18964_2824# VSS 0.33311f
C5191 a_18516_2824# VSS 0.33309f
C5192 a_18068_2824# VSS 0.33307f
C5193 a_17620_2824# VSS 0.33235f
C5194 a_17172_2824# VSS 0.33303f
C5195 a_16724_2824# VSS 0.3322f
C5196 a_16276_2824# VSS 0.34898f
C5197 a_15828_2824# VSS 0.33435f
C5198 a_15380_2824# VSS 0.3343f
C5199 a_14932_2824# VSS 0.3343f
C5200 a_14484_2824# VSS 0.3343f
C5201 a_14036_2824# VSS 0.33525f
C5202 a_13588_2824# VSS 0.33772f
C5203 a_13140_2824# VSS 0.33958f
C5204 a_12692_2824# VSS 0.35366f
C5205 a_12020_2824# VSS 0.37266f
C5206 a_11572_2824# VSS 0.33206f
C5207 a_11124_2824# VSS 0.33201f
C5208 a_10676_2824# VSS 0.33199f
C5209 a_10228_2824# VSS 0.33197f
C5210 a_9780_2824# VSS 0.33197f
C5211 a_9332_2824# VSS 0.33197f
C5212 a_8884_2824# VSS 0.33197f
C5213 a_8436_2824# VSS 0.34796f
C5214 a_7988_2824# VSS 0.33325f
C5215 a_7540_2824# VSS 0.33321f
C5216 a_7092_2824# VSS 0.33321f
C5217 a_6644_2824# VSS 0.33321f
C5218 a_6196_2824# VSS 0.33471f
C5219 a_5748_2824# VSS 0.33685f
C5220 a_5300_2824# VSS 0.33882f
C5221 a_4852_2824# VSS 0.35684f
C5222 a_4068_2824# VSS 0.32514f
C5223 a_3620_2824# VSS 0.31337f
C5224 a_3172_2824# VSS 0.31333f
C5225 a_2724_2824# VSS 0.31332f
C5226 a_2276_2824# VSS 0.3133f
C5227 a_1828_2824# VSS 0.3133f
C5228 a_1380_2824# VSS 0.3133f
C5229 a_932_2824# VSS 0.33989f
C5230 a_21964_2727# VSS 0.16795f
C5231 a_21516_2727# VSS 0.17002f
C5232 a_21068_2727# VSS 0.17166f
C5233 a_20620_2727# VSS 0.176f
C5234 a_19948_2727# VSS 0.23032f
C5235 a_19500_2727# VSS 0.17284f
C5236 a_19052_2727# VSS 0.16488f
C5237 a_18604_2727# VSS 0.16488f
C5238 a_18156_2727# VSS 0.16488f
C5239 a_17708_2727# VSS 0.16488f
C5240 a_17260_2727# VSS 0.16488f
C5241 a_16812_2727# VSS 0.16488f
C5242 a_16364_2727# VSS 0.16653f
C5243 a_15916_2727# VSS 0.16505f
C5244 a_15468_2727# VSS 0.16504f
C5245 a_15020_2727# VSS 0.16504f
C5246 a_14572_2727# VSS 0.16504f
C5247 a_14124_2727# VSS 0.1651f
C5248 a_13676_2727# VSS 0.16848f
C5249 a_13228_2727# VSS 0.17022f
C5250 a_12780_2727# VSS 0.17649f
C5251 a_12108_2727# VSS 0.21809f
C5252 a_11660_2727# VSS 0.17088f
C5253 a_11212_2727# VSS 0.16488f
C5254 a_10764_2727# VSS 0.16488f
C5255 a_10316_2727# VSS 0.16488f
C5256 a_9868_2727# VSS 0.16488f
C5257 a_9420_2727# VSS 0.16488f
C5258 a_8972_2727# VSS 0.16488f
C5259 a_8524_2727# VSS 0.16653f
C5260 a_8076_2727# VSS 0.16505f
C5261 a_7628_2727# VSS 0.16504f
C5262 a_7180_2727# VSS 0.16504f
C5263 a_6732_2727# VSS 0.16504f
C5264 a_6284_2727# VSS 0.16575f
C5265 a_5836_2727# VSS 0.16869f
C5266 a_5388_2727# VSS 0.17054f
C5267 a_4940_2727# VSS 0.17743f
C5268 a_4156_2727# VSS 0.16375f
C5269 a_3708_2727# VSS 0.16198f
C5270 a_3260_2727# VSS 0.16198f
C5271 a_2812_2727# VSS 0.16198f
C5272 a_2364_2727# VSS 0.16198f
C5273 a_1916_2727# VSS 0.16198f
C5274 a_1468_2727# VSS 0.16198f
C5275 a_1020_2727# VSS 0.17212f
C5276 a_22076_3160# VSS 0.18775f
C5277 a_21628_3160# VSS 0.17167f
C5278 a_21180_3160# VSS 0.17102f
C5279 a_20732_3160# VSS 0.17176f
C5280 a_20284_3160# VSS 0.17944f
C5281 a_19836_3160# VSS 0.20392f
C5282 a_19388_3160# VSS 0.16495f
C5283 a_18940_3160# VSS 0.16388f
C5284 a_18492_3160# VSS 0.16388f
C5285 a_18044_3160# VSS 0.16388f
C5286 a_17596_3160# VSS 0.16388f
C5287 a_17148_3160# VSS 0.16388f
C5288 a_16700_3160# VSS 0.16759f
C5289 a_21988_3204# VSS 0.34944f
C5290 a_21540_3204# VSS 0.33789f
C5291 a_21092_3204# VSS 0.33943f
C5292 a_20644_3204# VSS 0.34068f
C5293 a_20196_3204# VSS 0.38125f
C5294 a_19748_3204# VSS 0.3465f
C5295 a_19300_3204# VSS 0.331f
C5296 a_18852_3204# VSS 0.33095f
C5297 a_18404_3204# VSS 0.33093f
C5298 a_17956_3204# VSS 0.33091f
C5299 a_17508_3204# VSS 0.33091f
C5300 a_17060_3204# VSS 0.33091f
C5301 a_16612_3204# VSS 0.34162f
C5302 a_16028_3160# VSS 0.16991f
C5303 a_15580_3160# VSS 0.16836f
C5304 a_15132_3160# VSS 0.16488f
C5305 a_14684_3160# VSS 0.16488f
C5306 a_14236_3160# VSS 0.16488f
C5307 a_13788_3160# VSS 0.16799f
C5308 a_13340_3160# VSS 0.16956f
C5309 a_12892_3160# VSS 0.17177f
C5310 a_12444_3160# VSS 0.19083f
C5311 a_11996_3160# VSS 0.18981f
C5312 a_11548_3160# VSS 0.16507f
C5313 a_11100_3160# VSS 0.16504f
C5314 a_10652_3160# VSS 0.16504f
C5315 a_10204_3160# VSS 0.16504f
C5316 a_9756_3160# VSS 0.16504f
C5317 a_9308_3160# VSS 0.16504f
C5318 a_8860_3160# VSS 0.16854f
C5319 a_15940_3204# VSS 0.34558f
C5320 a_15492_3204# VSS 0.33168f
C5321 a_15044_3204# VSS 0.33168f
C5322 a_14596_3204# VSS 0.33168f
C5323 a_14148_3204# VSS 0.33168f
C5324 a_13700_3204# VSS 0.33475f
C5325 a_13252_3204# VSS 0.33642f
C5326 a_12804_3204# VSS 0.339f
C5327 a_12356_3204# VSS 0.39062f
C5328 a_11908_3204# VSS 0.3418f
C5329 a_11460_3204# VSS 0.333f
C5330 a_11012_3204# VSS 0.33295f
C5331 a_10564_3204# VSS 0.33294f
C5332 a_10116_3204# VSS 0.33292f
C5333 a_9668_3204# VSS 0.33292f
C5334 a_9220_3204# VSS 0.33292f
C5335 a_8772_3204# VSS 0.34353f
C5336 a_8188_3160# VSS 0.16991f
C5337 a_7740_3160# VSS 0.16836f
C5338 a_7292_3160# VSS 0.16488f
C5339 a_6844_3160# VSS 0.16488f
C5340 a_6396_3160# VSS 0.16488f
C5341 a_5948_3160# VSS 0.16818f
C5342 a_5500_3160# VSS 0.16985f
C5343 a_5052_3160# VSS 0.1721f
C5344 a_4604_3160# VSS 0.2043f
C5345 a_4156_3160# VSS 0.17427f
C5346 a_3708_3160# VSS 0.16314f
C5347 a_3260_3160# VSS 0.16314f
C5348 a_2812_3160# VSS 0.16314f
C5349 a_2364_3160# VSS 0.16314f
C5350 a_1916_3160# VSS 0.16314f
C5351 a_1468_3160# VSS 0.16314f
C5352 a_1020_3160# VSS 0.17306f
C5353 a_8100_3204# VSS 0.34558f
C5354 a_7652_3204# VSS 0.33168f
C5355 a_7204_3204# VSS 0.33168f
C5356 a_6756_3204# VSS 0.33168f
C5357 a_6308_3204# VSS 0.33219f
C5358 a_5860_3204# VSS 0.33495f
C5359 a_5412_3204# VSS 0.33673f
C5360 a_4964_3204# VSS 0.33949f
C5361 a_4516_3204# VSS 0.40303f
C5362 a_4068_3204# VSS 0.32255f
C5363 a_3620_3204# VSS 0.31538f
C5364 a_3172_3204# VSS 0.31534f
C5365 a_2724_3204# VSS 0.31532f
C5366 a_2276_3204# VSS 0.31531f
C5367 a_1828_3204# VSS 0.31531f
C5368 a_1380_3204# VSS 0.31531f
C5369 a_932_3204# VSS 0.34181f
C5370 a_21876_4392# VSS 0.34362f
C5371 a_21428_4392# VSS 0.33947f
C5372 a_20980_4392# VSS 0.34119f
C5373 a_20532_4392# VSS 0.35357f
C5374 a_19860_4392# VSS 0.38306f
C5375 a_19412_4392# VSS 0.33295f
C5376 a_18964_4392# VSS 0.33173f
C5377 a_18516_4392# VSS 0.3317f
C5378 a_18068_4392# VSS 0.33168f
C5379 a_17620_4392# VSS 0.33168f
C5380 a_17172_4392# VSS 0.33168f
C5381 a_16724_4392# VSS 0.33168f
C5382 a_16276_4392# VSS 0.34657f
C5383 a_15828_4392# VSS 0.33296f
C5384 a_15380_4392# VSS 0.33292f
C5385 a_14932_4392# VSS 0.33292f
C5386 a_14484_4392# VSS 0.33292f
C5387 a_14036_4392# VSS 0.33386f
C5388 a_13588_4392# VSS 0.33633f
C5389 a_13140_4392# VSS 0.33819f
C5390 a_12692_4392# VSS 0.35227f
C5391 a_12020_4392# VSS 0.37071f
C5392 a_11572_4392# VSS 0.33178f
C5393 a_11124_4392# VSS 0.33172f
C5394 a_10676_4392# VSS 0.3317f
C5395 a_10228_4392# VSS 0.33168f
C5396 a_9780_4392# VSS 0.33168f
C5397 a_9332_4392# VSS 0.33168f
C5398 a_8884_4392# VSS 0.33168f
C5399 a_8436_4392# VSS 0.34657f
C5400 a_7988_4392# VSS 0.33296f
C5401 a_7540_4392# VSS 0.33292f
C5402 a_7092_4392# VSS 0.33292f
C5403 a_6644_4392# VSS 0.33292f
C5404 a_6196_4392# VSS 0.33442f
C5405 a_5748_4392# VSS 0.33656f
C5406 a_5300_4392# VSS 0.33853f
C5407 a_4852_4392# VSS 0.35655f
C5408 a_4068_4392# VSS 0.32514f
C5409 a_3620_4392# VSS 0.31337f
C5410 a_3172_4392# VSS 0.31333f
C5411 a_2724_4392# VSS 0.31332f
C5412 a_2276_4392# VSS 0.3133f
C5413 a_1828_4392# VSS 0.3133f
C5414 a_1380_4392# VSS 0.3133f
C5415 a_932_4392# VSS 0.33989f
C5416 a_21964_4295# VSS 0.16795f
C5417 a_21516_4295# VSS 0.17002f
C5418 a_21068_4295# VSS 0.17166f
C5419 a_20620_4295# VSS 0.176f
C5420 a_19948_4295# VSS 0.23032f
C5421 a_19500_4295# VSS 0.17284f
C5422 a_19052_4295# VSS 0.16488f
C5423 a_18604_4295# VSS 0.16488f
C5424 a_18156_4295# VSS 0.16488f
C5425 a_17708_4295# VSS 0.16488f
C5426 a_17260_4295# VSS 0.16488f
C5427 a_16812_4295# VSS 0.16488f
C5428 a_16364_4295# VSS 0.16653f
C5429 a_15916_4295# VSS 0.16505f
C5430 a_15468_4295# VSS 0.16504f
C5431 a_15020_4295# VSS 0.16504f
C5432 a_14572_4295# VSS 0.16504f
C5433 a_14124_4295# VSS 0.1651f
C5434 a_13676_4295# VSS 0.16848f
C5435 a_13228_4295# VSS 0.17022f
C5436 a_12780_4295# VSS 0.17649f
C5437 a_12108_4295# VSS 0.21809f
C5438 a_11660_4295# VSS 0.17088f
C5439 a_11212_4295# VSS 0.16488f
C5440 a_10764_4295# VSS 0.16488f
C5441 a_10316_4295# VSS 0.16488f
C5442 a_9868_4295# VSS 0.16488f
C5443 a_9420_4295# VSS 0.16488f
C5444 a_8972_4295# VSS 0.16488f
C5445 a_8524_4295# VSS 0.16653f
C5446 a_8076_4295# VSS 0.16505f
C5447 a_7628_4295# VSS 0.16504f
C5448 a_7180_4295# VSS 0.16504f
C5449 a_6732_4295# VSS 0.16504f
C5450 a_6284_4295# VSS 0.16575f
C5451 a_5836_4295# VSS 0.16869f
C5452 a_5388_4295# VSS 0.17054f
C5453 a_4940_4295# VSS 0.17743f
C5454 a_4156_4295# VSS 0.16375f
C5455 a_3708_4295# VSS 0.16198f
C5456 a_3260_4295# VSS 0.16198f
C5457 a_2812_4295# VSS 0.16198f
C5458 a_2364_4295# VSS 0.16198f
C5459 a_1916_4295# VSS 0.16198f
C5460 a_1468_4295# VSS 0.16198f
C5461 a_1020_4295# VSS 0.17212f
C5462 a_22076_4728# VSS 0.18775f
C5463 a_21628_4728# VSS 0.17167f
C5464 a_21180_4728# VSS 0.17102f
C5465 a_20732_4728# VSS 0.17176f
C5466 a_20284_4728# VSS 0.17944f
C5467 a_19836_4728# VSS 0.20392f
C5468 a_19388_4728# VSS 0.16495f
C5469 a_18940_4728# VSS 0.16388f
C5470 a_18492_4728# VSS 0.16388f
C5471 a_18044_4728# VSS 0.16388f
C5472 a_17596_4728# VSS 0.16388f
C5473 a_17148_4728# VSS 0.16388f
C5474 a_16700_4728# VSS 0.16759f
C5475 a_21988_4772# VSS 0.34944f
C5476 a_21540_4772# VSS 0.33789f
C5477 a_21092_4772# VSS 0.33943f
C5478 a_20644_4772# VSS 0.34068f
C5479 a_20196_4772# VSS 0.38125f
C5480 a_19748_4772# VSS 0.3465f
C5481 a_19300_4772# VSS 0.331f
C5482 a_18852_4772# VSS 0.33095f
C5483 a_18404_4772# VSS 0.33093f
C5484 a_17956_4772# VSS 0.33091f
C5485 a_17508_4772# VSS 0.33091f
C5486 a_17060_4772# VSS 0.33091f
C5487 a_16612_4772# VSS 0.34162f
C5488 a_16028_4728# VSS 0.16991f
C5489 a_15580_4728# VSS 0.16836f
C5490 a_15132_4728# VSS 0.16488f
C5491 a_14684_4728# VSS 0.16488f
C5492 a_14236_4728# VSS 0.16488f
C5493 a_13788_4728# VSS 0.16799f
C5494 a_13340_4728# VSS 0.16956f
C5495 a_12892_4728# VSS 0.17177f
C5496 a_12444_4728# VSS 0.19083f
C5497 a_11996_4728# VSS 0.18981f
C5498 a_11548_4728# VSS 0.16507f
C5499 a_11100_4728# VSS 0.16504f
C5500 a_10652_4728# VSS 0.16504f
C5501 a_10204_4728# VSS 0.16504f
C5502 a_9756_4728# VSS 0.16504f
C5503 a_9308_4728# VSS 0.16504f
C5504 a_8860_4728# VSS 0.16854f
C5505 a_15940_4772# VSS 0.34558f
C5506 a_15492_4772# VSS 0.33168f
C5507 a_15044_4772# VSS 0.33168f
C5508 a_14596_4772# VSS 0.33168f
C5509 a_14148_4772# VSS 0.33168f
C5510 a_13700_4772# VSS 0.33475f
C5511 a_13252_4772# VSS 0.33642f
C5512 a_12804_4772# VSS 0.339f
C5513 a_12356_4772# VSS 0.39062f
C5514 a_11908_4772# VSS 0.3418f
C5515 a_11460_4772# VSS 0.333f
C5516 a_11012_4772# VSS 0.33292f
C5517 a_10564_4772# VSS 0.33292f
C5518 a_10116_4772# VSS 0.33292f
C5519 a_9668_4772# VSS 0.33292f
C5520 a_9220_4772# VSS 0.33292f
C5521 a_8772_4772# VSS 0.34353f
C5522 a_8188_4728# VSS 0.16991f
C5523 a_7740_4728# VSS 0.16836f
C5524 a_7292_4728# VSS 0.16488f
C5525 a_6844_4728# VSS 0.16488f
C5526 a_6396_4728# VSS 0.16488f
C5527 a_5948_4728# VSS 0.16818f
C5528 a_5500_4728# VSS 0.16985f
C5529 a_5052_4728# VSS 0.1721f
C5530 a_4604_4728# VSS 0.2043f
C5531 a_4156_4728# VSS 0.17427f
C5532 a_3708_4728# VSS 0.16314f
C5533 a_3260_4728# VSS 0.16314f
C5534 a_2812_4728# VSS 0.16314f
C5535 a_2364_4728# VSS 0.16314f
C5536 a_1916_4728# VSS 0.16314f
C5537 a_1468_4728# VSS 0.16314f
C5538 a_1020_4728# VSS 0.17306f
C5539 a_8100_4772# VSS 0.34558f
C5540 a_7652_4772# VSS 0.33168f
C5541 a_7204_4772# VSS 0.33168f
C5542 a_6756_4772# VSS 0.33168f
C5543 a_6308_4772# VSS 0.33219f
C5544 a_5860_4772# VSS 0.33495f
C5545 a_5412_4772# VSS 0.33673f
C5546 a_4964_4772# VSS 0.33949f
C5547 a_4516_4772# VSS 0.40303f
C5548 a_4068_4772# VSS 0.32255f
C5549 a_3620_4772# VSS 0.31538f
C5550 a_3172_4772# VSS 0.31534f
C5551 a_2724_4772# VSS 0.31532f
C5552 a_2276_4772# VSS 0.31531f
C5553 a_1828_4772# VSS 0.31531f
C5554 a_1380_4772# VSS 0.31531f
C5555 a_932_4772# VSS 0.34181f
C5556 a_21876_5960# VSS 0.34362f
C5557 a_21428_5960# VSS 0.33947f
C5558 a_20980_5960# VSS 0.34119f
C5559 a_20532_5960# VSS 0.35357f
C5560 a_19860_5960# VSS 0.38306f
C5561 a_19412_5960# VSS 0.33295f
C5562 a_18964_5960# VSS 0.33173f
C5563 a_18516_5960# VSS 0.3317f
C5564 a_18068_5960# VSS 0.33168f
C5565 a_17620_5960# VSS 0.33168f
C5566 a_17172_5960# VSS 0.33168f
C5567 a_16724_5960# VSS 0.33168f
C5568 a_16276_5960# VSS 0.34657f
C5569 a_15828_5960# VSS 0.33296f
C5570 a_15380_5960# VSS 0.33292f
C5571 a_14932_5960# VSS 0.33292f
C5572 a_14484_5960# VSS 0.33292f
C5573 a_14036_5960# VSS 0.33386f
C5574 a_13588_5960# VSS 0.33633f
C5575 a_13140_5960# VSS 0.33819f
C5576 a_12692_5960# VSS 0.35227f
C5577 a_12020_5960# VSS 0.37071f
C5578 a_11572_5960# VSS 0.33178f
C5579 a_11124_5960# VSS 0.33168f
C5580 a_10676_5960# VSS 0.33168f
C5581 a_10228_5960# VSS 0.33168f
C5582 a_9780_5960# VSS 0.33168f
C5583 a_9332_5960# VSS 0.33168f
C5584 a_8884_5960# VSS 0.33168f
C5585 a_8436_5960# VSS 0.34657f
C5586 a_7988_5960# VSS 0.33296f
C5587 a_7540_5960# VSS 0.33292f
C5588 a_7092_5960# VSS 0.33292f
C5589 a_6644_5960# VSS 0.33292f
C5590 a_6196_5960# VSS 0.33442f
C5591 a_5748_5960# VSS 0.33656f
C5592 a_5300_5960# VSS 0.33853f
C5593 a_4852_5960# VSS 0.35655f
C5594 a_4068_5960# VSS 0.32514f
C5595 a_3620_5960# VSS 0.31337f
C5596 a_3172_5960# VSS 0.31333f
C5597 a_2724_5960# VSS 0.31332f
C5598 a_2276_5960# VSS 0.3133f
C5599 a_1828_5960# VSS 0.3133f
C5600 a_1380_5960# VSS 0.3133f
C5601 a_932_5960# VSS 0.33989f
C5602 a_21964_5863# VSS 0.16795f
C5603 a_21516_5863# VSS 0.17002f
C5604 a_21068_5863# VSS 0.17166f
C5605 a_20620_5863# VSS 0.176f
C5606 a_19948_5863# VSS 0.23032f
C5607 a_19500_5863# VSS 0.17284f
C5608 a_19052_5863# VSS 0.16488f
C5609 a_18604_5863# VSS 0.16488f
C5610 a_18156_5863# VSS 0.16488f
C5611 a_17708_5863# VSS 0.16488f
C5612 a_17260_5863# VSS 0.16488f
C5613 a_16812_5863# VSS 0.16488f
C5614 a_16364_5863# VSS 0.16653f
C5615 a_15916_5863# VSS 0.16505f
C5616 a_15468_5863# VSS 0.16504f
C5617 a_15020_5863# VSS 0.16504f
C5618 a_14572_5863# VSS 0.16504f
C5619 a_14124_5863# VSS 0.1651f
C5620 a_13676_5863# VSS 0.16848f
C5621 a_13228_5863# VSS 0.17022f
C5622 a_12780_5863# VSS 0.17649f
C5623 a_12108_5863# VSS 0.21809f
C5624 a_11660_5863# VSS 0.17088f
C5625 a_11212_5863# VSS 0.16488f
C5626 a_10764_5863# VSS 0.16488f
C5627 a_10316_5863# VSS 0.16488f
C5628 a_9868_5863# VSS 0.16488f
C5629 a_9420_5863# VSS 0.16488f
C5630 a_8972_5863# VSS 0.16488f
C5631 a_8524_5863# VSS 0.16653f
C5632 a_8076_5863# VSS 0.16505f
C5633 a_7628_5863# VSS 0.16504f
C5634 a_7180_5863# VSS 0.16504f
C5635 a_6732_5863# VSS 0.16504f
C5636 a_6284_5863# VSS 0.16575f
C5637 a_5836_5863# VSS 0.16869f
C5638 a_5388_5863# VSS 0.17054f
C5639 a_4940_5863# VSS 0.17743f
C5640 a_4156_5863# VSS 0.16375f
C5641 a_3708_5863# VSS 0.16198f
C5642 a_3260_5863# VSS 0.16198f
C5643 a_2812_5863# VSS 0.16198f
C5644 a_2364_5863# VSS 0.16198f
C5645 a_1916_5863# VSS 0.16198f
C5646 a_1468_5863# VSS 0.16198f
C5647 a_1020_5863# VSS 0.17212f
C5648 a_22076_6296# VSS 0.18775f
C5649 a_21628_6296# VSS 0.17167f
C5650 a_21180_6296# VSS 0.17102f
C5651 a_20732_6296# VSS 0.17176f
C5652 a_20284_6296# VSS 0.17944f
C5653 a_19836_6296# VSS 0.20392f
C5654 a_19388_6296# VSS 0.16495f
C5655 a_18940_6296# VSS 0.16388f
C5656 a_18492_6296# VSS 0.16388f
C5657 a_18044_6296# VSS 0.16388f
C5658 a_17596_6296# VSS 0.16388f
C5659 a_17148_6296# VSS 0.16388f
C5660 a_16700_6296# VSS 0.16759f
C5661 a_21988_6340# VSS 0.34944f
C5662 a_21540_6340# VSS 0.33789f
C5663 a_21092_6340# VSS 0.33943f
C5664 a_20644_6340# VSS 0.34068f
C5665 a_20196_6340# VSS 0.38125f
C5666 a_19748_6340# VSS 0.3465f
C5667 a_19300_6340# VSS 0.331f
C5668 a_18852_6340# VSS 0.33095f
C5669 a_18404_6340# VSS 0.33093f
C5670 a_17956_6340# VSS 0.33091f
C5671 a_17508_6340# VSS 0.33091f
C5672 a_17060_6340# VSS 0.33091f
C5673 a_16612_6340# VSS 0.34162f
C5674 a_16028_6296# VSS 0.16991f
C5675 a_15580_6296# VSS 0.16836f
C5676 a_15132_6296# VSS 0.16488f
C5677 a_14684_6296# VSS 0.16488f
C5678 a_14236_6296# VSS 0.16488f
C5679 a_13788_6296# VSS 0.16799f
C5680 a_13340_6296# VSS 0.16956f
C5681 a_12892_6296# VSS 0.17177f
C5682 a_12444_6296# VSS 0.19083f
C5683 a_11996_6296# VSS 0.18981f
C5684 a_11548_6296# VSS 0.16507f
C5685 a_11100_6296# VSS 0.16504f
C5686 a_10652_6296# VSS 0.16504f
C5687 a_10204_6296# VSS 0.16504f
C5688 a_9756_6296# VSS 0.16504f
C5689 a_9308_6296# VSS 0.16504f
C5690 a_8860_6296# VSS 0.16854f
C5691 a_15940_6340# VSS 0.34558f
C5692 a_15492_6340# VSS 0.33168f
C5693 a_15044_6340# VSS 0.33168f
C5694 a_14596_6340# VSS 0.33168f
C5695 a_14148_6340# VSS 0.33168f
C5696 a_13700_6340# VSS 0.33475f
C5697 a_13252_6340# VSS 0.33642f
C5698 a_12804_6340# VSS 0.339f
C5699 a_12356_6340# VSS 0.39062f
C5700 a_11908_6340# VSS 0.3418f
C5701 a_11460_6340# VSS 0.333f
C5702 a_11012_6340# VSS 0.33292f
C5703 a_10564_6340# VSS 0.33292f
C5704 a_10116_6340# VSS 0.33292f
C5705 a_9668_6340# VSS 0.33292f
C5706 a_9220_6340# VSS 0.33292f
C5707 a_8772_6340# VSS 0.34353f
C5708 a_8188_6296# VSS 0.16991f
C5709 a_7740_6296# VSS 0.16836f
C5710 a_7292_6296# VSS 0.16488f
C5711 a_6844_6296# VSS 0.16488f
C5712 a_6396_6296# VSS 0.16488f
C5713 a_5948_6296# VSS 0.16818f
C5714 a_5500_6296# VSS 0.16985f
C5715 a_5052_6296# VSS 0.1721f
C5716 a_4604_6296# VSS 0.2043f
C5717 a_4156_6296# VSS 0.17427f
C5718 a_3708_6296# VSS 0.16314f
C5719 a_3260_6296# VSS 0.16314f
C5720 a_2812_6296# VSS 0.16314f
C5721 a_2364_6296# VSS 0.16314f
C5722 a_1916_6296# VSS 0.16314f
C5723 a_1468_6296# VSS 0.16314f
C5724 a_1020_6296# VSS 0.17306f
C5725 a_8100_6340# VSS 0.34558f
C5726 a_7652_6340# VSS 0.33168f
C5727 a_7204_6340# VSS 0.33168f
C5728 a_6756_6340# VSS 0.33168f
C5729 a_6308_6340# VSS 0.33219f
C5730 a_5860_6340# VSS 0.33495f
C5731 a_5412_6340# VSS 0.33673f
C5732 a_4964_6340# VSS 0.33949f
C5733 a_4516_6340# VSS 0.40303f
C5734 a_4068_6340# VSS 0.32255f
C5735 a_3620_6340# VSS 0.31538f
C5736 a_3172_6340# VSS 0.31534f
C5737 a_2724_6340# VSS 0.31532f
C5738 a_2276_6340# VSS 0.31531f
C5739 a_1828_6340# VSS 0.31531f
C5740 a_1380_6340# VSS 0.31531f
C5741 a_932_6340# VSS 0.34181f
C5742 a_21876_7528# VSS 0.34362f
C5743 a_21428_7528# VSS 0.33947f
C5744 a_20980_7528# VSS 0.34119f
C5745 a_20532_7528# VSS 0.35357f
C5746 a_19860_7528# VSS 0.38306f
C5747 a_19412_7528# VSS 0.33295f
C5748 a_18964_7528# VSS 0.33173f
C5749 a_18516_7528# VSS 0.3317f
C5750 a_18068_7528# VSS 0.33168f
C5751 a_17620_7528# VSS 0.33168f
C5752 a_17172_7528# VSS 0.33168f
C5753 a_16724_7528# VSS 0.33168f
C5754 a_16276_7528# VSS 0.34657f
C5755 a_15828_7528# VSS 0.33296f
C5756 a_15380_7528# VSS 0.33292f
C5757 a_14932_7528# VSS 0.33292f
C5758 a_14484_7528# VSS 0.33292f
C5759 a_14036_7528# VSS 0.33386f
C5760 a_13588_7528# VSS 0.33633f
C5761 a_13140_7528# VSS 0.33819f
C5762 a_12692_7528# VSS 0.35227f
C5763 a_12020_7528# VSS 0.37071f
C5764 a_11572_7528# VSS 0.33178f
C5765 a_11124_7528# VSS 0.33168f
C5766 a_10676_7528# VSS 0.33168f
C5767 a_10228_7528# VSS 0.33168f
C5768 a_9780_7528# VSS 0.33168f
C5769 a_9332_7528# VSS 0.33168f
C5770 a_8884_7528# VSS 0.33168f
C5771 a_8436_7528# VSS 0.34657f
C5772 a_7988_7528# VSS 0.33296f
C5773 a_7540_7528# VSS 0.33292f
C5774 a_7092_7528# VSS 0.33292f
C5775 a_6644_7528# VSS 0.33292f
C5776 a_6196_7528# VSS 0.33442f
C5777 a_5748_7528# VSS 0.33656f
C5778 a_5300_7528# VSS 0.33853f
C5779 a_4852_7528# VSS 0.35655f
C5780 a_4068_7528# VSS 0.32514f
C5781 a_3620_7528# VSS 0.31337f
C5782 a_3172_7528# VSS 0.31333f
C5783 a_2724_7528# VSS 0.31332f
C5784 a_2276_7528# VSS 0.3133f
C5785 a_1828_7528# VSS 0.3133f
C5786 a_1380_7528# VSS 0.3133f
C5787 a_932_7528# VSS 0.33989f
C5788 a_21964_7431# VSS 0.16795f
C5789 a_21516_7431# VSS 0.17002f
C5790 a_21068_7431# VSS 0.17166f
C5791 a_20620_7431# VSS 0.176f
C5792 a_19948_7431# VSS 0.23032f
C5793 a_19500_7431# VSS 0.17284f
C5794 a_19052_7431# VSS 0.16488f
C5795 a_18604_7431# VSS 0.16488f
C5796 a_18156_7431# VSS 0.16488f
C5797 a_17708_7431# VSS 0.16488f
C5798 a_17260_7431# VSS 0.16488f
C5799 a_16812_7431# VSS 0.16488f
C5800 a_16364_7431# VSS 0.16653f
C5801 a_15916_7431# VSS 0.16505f
C5802 a_15468_7431# VSS 0.16504f
C5803 a_15020_7431# VSS 0.16504f
C5804 a_14572_7431# VSS 0.16504f
C5805 a_14124_7431# VSS 0.1651f
C5806 a_13676_7431# VSS 0.16848f
C5807 a_13228_7431# VSS 0.17022f
C5808 a_12780_7431# VSS 0.17649f
C5809 a_12108_7431# VSS 0.21809f
C5810 a_11660_7431# VSS 0.17088f
C5811 a_11212_7431# VSS 0.16488f
C5812 a_10764_7431# VSS 0.16488f
C5813 a_10316_7431# VSS 0.16488f
C5814 a_9868_7431# VSS 0.16488f
C5815 a_9420_7431# VSS 0.16488f
C5816 a_8972_7431# VSS 0.16488f
C5817 a_8524_7431# VSS 0.16653f
C5818 a_8076_7431# VSS 0.16505f
C5819 a_7628_7431# VSS 0.16504f
C5820 a_7180_7431# VSS 0.16504f
C5821 a_6732_7431# VSS 0.16504f
C5822 a_6284_7431# VSS 0.16575f
C5823 a_5836_7431# VSS 0.16869f
C5824 a_5388_7431# VSS 0.17054f
C5825 a_4940_7431# VSS 0.17743f
C5826 a_4156_7431# VSS 0.16375f
C5827 a_3708_7431# VSS 0.16198f
C5828 a_3260_7431# VSS 0.16198f
C5829 a_2812_7431# VSS 0.16198f
C5830 a_2364_7431# VSS 0.16198f
C5831 a_1916_7431# VSS 0.16198f
C5832 a_1468_7431# VSS 0.16198f
C5833 a_1020_7431# VSS 0.17212f
C5834 a_22076_7864# VSS 0.18775f
C5835 a_21628_7864# VSS 0.17167f
C5836 a_21180_7864# VSS 0.17102f
C5837 a_20732_7864# VSS 0.17176f
C5838 a_20284_7864# VSS 0.17944f
C5839 a_19836_7864# VSS 0.20392f
C5840 a_19388_7864# VSS 0.16495f
C5841 a_18940_7864# VSS 0.16388f
C5842 a_18492_7864# VSS 0.16388f
C5843 a_18044_7864# VSS 0.16388f
C5844 a_17596_7864# VSS 0.16388f
C5845 a_17148_7864# VSS 0.16388f
C5846 a_16700_7864# VSS 0.16759f
C5847 a_21988_7908# VSS 0.34944f
C5848 a_21540_7908# VSS 0.33789f
C5849 a_21092_7908# VSS 0.33943f
C5850 a_20644_7908# VSS 0.34068f
C5851 a_20196_7908# VSS 0.38125f
C5852 a_19748_7908# VSS 0.3465f
C5853 a_19300_7908# VSS 0.331f
C5854 a_18852_7908# VSS 0.33095f
C5855 a_18404_7908# VSS 0.33093f
C5856 a_17956_7908# VSS 0.33091f
C5857 a_17508_7908# VSS 0.33091f
C5858 a_17060_7908# VSS 0.33091f
C5859 a_16612_7908# VSS 0.34162f
C5860 a_16028_7864# VSS 0.16991f
C5861 a_15580_7864# VSS 0.16836f
C5862 a_15132_7864# VSS 0.16488f
C5863 a_14684_7864# VSS 0.16488f
C5864 a_14236_7864# VSS 0.16488f
C5865 a_13788_7864# VSS 0.16799f
C5866 a_13340_7864# VSS 0.16956f
C5867 a_12892_7864# VSS 0.17177f
C5868 a_12444_7864# VSS 0.19083f
C5869 a_11996_7864# VSS 0.18981f
C5870 a_11548_7864# VSS 0.16507f
C5871 a_11100_7864# VSS 0.16504f
C5872 a_10652_7864# VSS 0.16504f
C5873 a_10204_7864# VSS 0.16504f
C5874 a_9756_7864# VSS 0.16504f
C5875 a_9308_7864# VSS 0.16504f
C5876 a_8860_7864# VSS 0.16854f
C5877 a_15940_7908# VSS 0.34693f
C5878 a_15492_7908# VSS 0.33197f
C5879 a_15044_7908# VSS 0.33197f
C5880 a_14596_7908# VSS 0.33197f
C5881 a_14148_7908# VSS 0.33197f
C5882 a_13700_7908# VSS 0.33504f
C5883 a_13252_7908# VSS 0.33671f
C5884 a_12804_7908# VSS 0.33929f
C5885 a_12356_7908# VSS 0.39236f
C5886 a_11908_7908# VSS 0.34319f
C5887 a_11460_7908# VSS 0.33439f
C5888 a_11012_7908# VSS 0.33292f
C5889 a_10564_7908# VSS 0.33292f
C5890 a_10116_7908# VSS 0.33292f
C5891 a_9668_7908# VSS 0.33292f
C5892 a_9220_7908# VSS 0.33292f
C5893 a_8772_7908# VSS 0.34353f
C5894 a_8188_7864# VSS 0.16991f
C5895 a_7740_7864# VSS 0.16836f
C5896 a_7292_7864# VSS 0.16488f
C5897 a_6844_7864# VSS 0.16488f
C5898 a_6396_7864# VSS 0.16488f
C5899 a_5948_7864# VSS 0.16818f
C5900 a_5500_7864# VSS 0.16985f
C5901 a_5052_7864# VSS 0.1721f
C5902 a_4604_7864# VSS 0.2043f
C5903 a_4156_7864# VSS 0.17427f
C5904 a_3708_7864# VSS 0.16314f
C5905 a_3260_7864# VSS 0.16314f
C5906 a_2812_7864# VSS 0.16314f
C5907 a_2364_7864# VSS 0.16314f
C5908 a_1916_7864# VSS 0.16314f
C5909 a_1468_7864# VSS 0.16314f
C5910 a_1020_7864# VSS 0.17306f
C5911 a_8100_7908# VSS 0.34558f
C5912 a_7652_7908# VSS 0.33168f
C5913 a_7204_7908# VSS 0.33168f
C5914 a_6756_7908# VSS 0.33168f
C5915 a_6308_7908# VSS 0.33219f
C5916 a_5860_7908# VSS 0.33495f
C5917 a_5412_7908# VSS 0.33673f
C5918 a_4964_7908# VSS 0.33949f
C5919 a_4516_7908# VSS 0.40303f
C5920 a_4068_7908# VSS 0.32255f
C5921 a_3620_7908# VSS 0.31538f
C5922 a_3172_7908# VSS 0.31534f
C5923 a_2724_7908# VSS 0.31532f
C5924 a_2276_7908# VSS 0.31531f
C5925 a_1828_7908# VSS 0.31531f
C5926 a_1380_7908# VSS 0.31531f
C5927 a_932_7908# VSS 0.34181f
C5928 a_21876_9096# VSS 0.34362f
C5929 a_21428_9096# VSS 0.33947f
C5930 a_20980_9096# VSS 0.34119f
C5931 a_20532_9096# VSS 0.35357f
C5932 a_19860_9096# VSS 0.38306f
C5933 a_19412_9096# VSS 0.33295f
C5934 a_18964_9096# VSS 0.33173f
C5935 a_18516_9096# VSS 0.3317f
C5936 a_18068_9096# VSS 0.33168f
C5937 a_17620_9096# VSS 0.33168f
C5938 a_17172_9096# VSS 0.33168f
C5939 a_16724_9096# VSS 0.33168f
C5940 a_16276_9096# VSS 0.34657f
C5941 a_15828_9096# VSS 0.33296f
C5942 a_15380_9096# VSS 0.33292f
C5943 a_14932_9096# VSS 0.33292f
C5944 a_14484_9096# VSS 0.33292f
C5945 a_14036_9096# VSS 0.33386f
C5946 a_13588_9096# VSS 0.33633f
C5947 a_13140_9096# VSS 0.33819f
C5948 a_12692_9096# VSS 0.35227f
C5949 a_12020_9096# VSS 0.37071f
C5950 a_11572_9096# VSS 0.33178f
C5951 a_11124_9096# VSS 0.33168f
C5952 a_10676_9096# VSS 0.33168f
C5953 a_10228_9096# VSS 0.33168f
C5954 a_9780_9096# VSS 0.33168f
C5955 a_9332_9096# VSS 0.33168f
C5956 a_8884_9096# VSS 0.33168f
C5957 a_8436_9096# VSS 0.34657f
C5958 a_7988_9096# VSS 0.33296f
C5959 a_7540_9096# VSS 0.33292f
C5960 a_7092_9096# VSS 0.33292f
C5961 a_6644_9096# VSS 0.33292f
C5962 a_6196_9096# VSS 0.33442f
C5963 a_5748_9096# VSS 0.33656f
C5964 a_5300_9096# VSS 0.33853f
C5965 a_4852_9096# VSS 0.35655f
C5966 a_4068_9096# VSS 0.32514f
C5967 a_3620_9096# VSS 0.31337f
C5968 a_3172_9096# VSS 0.31333f
C5969 a_2724_9096# VSS 0.31332f
C5970 a_2276_9096# VSS 0.3133f
C5971 a_1828_9096# VSS 0.3133f
C5972 a_1380_9096# VSS 0.3133f
C5973 a_932_9096# VSS 0.33989f
C5974 a_21964_8999# VSS 0.16795f
C5975 a_21516_8999# VSS 0.17002f
C5976 a_21068_8999# VSS 0.17166f
C5977 a_20620_8999# VSS 0.176f
C5978 a_19948_8999# VSS 0.23032f
C5979 a_19500_8999# VSS 0.17284f
C5980 a_19052_8999# VSS 0.16488f
C5981 a_18604_8999# VSS 0.16488f
C5982 a_18156_8999# VSS 0.16488f
C5983 a_17708_8999# VSS 0.16488f
C5984 a_17260_8999# VSS 0.16488f
C5985 a_16812_8999# VSS 0.16488f
C5986 a_16364_8999# VSS 0.16653f
C5987 a_15916_8999# VSS 0.16624f
C5988 a_15468_8999# VSS 0.16641f
C5989 a_15020_8999# VSS 0.1664f
C5990 a_14572_8999# VSS 0.1664f
C5991 a_14124_8999# VSS 0.16646f
C5992 a_13676_8999# VSS 0.16984f
C5993 a_13228_8999# VSS 0.17159f
C5994 a_12780_8999# VSS 0.17786f
C5995 a_12108_8999# VSS 0.21556f
C5996 a_11660_8999# VSS 0.17056f
C5997 a_11212_8999# VSS 0.16584f
C5998 a_10764_8999# VSS 0.16488f
C5999 a_10316_8999# VSS 0.16488f
C6000 a_9868_8999# VSS 0.16488f
C6001 a_9420_8999# VSS 0.16488f
C6002 a_8972_8999# VSS 0.16504f
C6003 a_8524_8999# VSS 0.16944f
C6004 a_8076_8999# VSS 0.16505f
C6005 a_7628_8999# VSS 0.16504f
C6006 a_7180_8999# VSS 0.16504f
C6007 a_6732_8999# VSS 0.16504f
C6008 a_6284_8999# VSS 0.16575f
C6009 a_5836_8999# VSS 0.16869f
C6010 a_5388_8999# VSS 0.17054f
C6011 a_4940_8999# VSS 0.17743f
C6012 a_4156_8999# VSS 0.16375f
C6013 a_3708_8999# VSS 0.16198f
C6014 a_3260_8999# VSS 0.16198f
C6015 a_2812_8999# VSS 0.16198f
C6016 a_2364_8999# VSS 0.16198f
C6017 a_1916_8999# VSS 0.16198f
C6018 a_1468_8999# VSS 0.16198f
C6019 a_1020_8999# VSS 0.17212f
C6020 a_22076_9432# VSS 0.18775f
C6021 a_21628_9432# VSS 0.17167f
C6022 a_21180_9432# VSS 0.17102f
C6023 a_20732_9432# VSS 0.17176f
C6024 a_20284_9432# VSS 0.17944f
C6025 a_19836_9432# VSS 0.20392f
C6026 a_19388_9432# VSS 0.16495f
C6027 a_18940_9432# VSS 0.16388f
C6028 a_18492_9432# VSS 0.16388f
C6029 a_18044_9432# VSS 0.16388f
C6030 a_17596_9432# VSS 0.16388f
C6031 a_17148_9432# VSS 0.16388f
C6032 a_16700_9432# VSS 0.16815f
C6033 a_21988_9476# VSS 0.34944f
C6034 a_21540_9476# VSS 0.33789f
C6035 a_21092_9476# VSS 0.33943f
C6036 a_20644_9476# VSS 0.34068f
C6037 a_20196_9476# VSS 0.38125f
C6038 a_19748_9476# VSS 0.3465f
C6039 a_19300_9476# VSS 0.331f
C6040 a_18852_9476# VSS 0.33095f
C6041 a_18404_9476# VSS 0.33093f
C6042 a_17956_9476# VSS 0.33091f
C6043 a_17508_9476# VSS 0.33091f
C6044 a_17060_9476# VSS 0.33091f
C6045 a_16612_9476# VSS 0.34731f
C6046 a_15692_9432# VSS 0.15201f
C6047 a_15244_9432# VSS 0.17123f
C6048 a_14796_9432# VSS 0.16688f
C6049 a_14348_9432# VSS 0.16688f
C6050 a_13900_9432# VSS 0.16921f
C6051 a_13452_9432# VSS 0.1711f
C6052 a_13004_9432# VSS 0.17318f
C6053 a_12556_9432# VSS 0.17603f
C6054 a_12108_9432# VSS 0.20945f
C6055 a_11100_9432# VSS 0.15135f
C6056 a_10652_9432# VSS 0.16851f
C6057 a_10204_9432# VSS 0.16808f
C6058 a_9756_9432# VSS 0.16678f
C6059 a_9308_9432# VSS 0.16678f
C6060 a_8860_9432# VSS 0.16996f
C6061 a_15604_9476# VSS 0.36252f
C6062 a_15156_9476# VSS 0.34622f
C6063 a_14708_9476# VSS 0.34622f
C6064 a_14260_9476# VSS 0.34623f
C6065 a_13812_9476# VSS 0.34683f
C6066 a_13364_9476# VSS 0.34923f
C6067 a_12916_9476# VSS 0.35024f
C6068 a_12468_9476# VSS 0.36545f
C6069 a_12020_9476# VSS 0.35887f
C6070 a_11012_9476# VSS 0.35435f
C6071 a_10564_9476# VSS 0.34055f
C6072 a_10116_9476# VSS 0.33763f
C6073 a_9668_9476# VSS 0.33763f
C6074 a_9220_9476# VSS 0.33628f
C6075 a_8772_9476# VSS 0.35479f
C6076 a_8188_9432# VSS 0.16991f
C6077 a_7740_9432# VSS 0.16836f
C6078 a_7292_9432# VSS 0.16488f
C6079 a_6844_9432# VSS 0.16488f
C6080 a_6396_9432# VSS 0.16488f
C6081 a_5948_9432# VSS 0.16818f
C6082 a_5500_9432# VSS 0.16985f
C6083 a_5052_9432# VSS 0.1721f
C6084 a_4604_9432# VSS 0.2043f
C6085 a_4156_9432# VSS 0.17427f
C6086 a_3708_9432# VSS 0.16314f
C6087 a_3260_9432# VSS 0.16314f
C6088 a_2812_9432# VSS 0.16314f
C6089 a_2364_9432# VSS 0.16314f
C6090 a_1916_9432# VSS 0.16314f
C6091 a_1468_9432# VSS 0.16314f
C6092 a_1020_9432# VSS 0.17306f
C6093 a_8100_9476# VSS 0.3456f
C6094 a_7652_9476# VSS 0.33303f
C6095 a_7204_9476# VSS 0.33168f
C6096 a_6756_9476# VSS 0.33168f
C6097 a_6308_9476# VSS 0.33219f
C6098 a_5860_9476# VSS 0.33495f
C6099 a_5412_9476# VSS 0.33673f
C6100 a_4964_9476# VSS 0.33949f
C6101 a_4516_9476# VSS 0.40303f
C6102 a_4068_9476# VSS 0.32255f
C6103 a_3620_9476# VSS 0.31538f
C6104 a_3172_9476# VSS 0.31534f
C6105 a_2724_9476# VSS 0.31532f
C6106 a_2276_9476# VSS 0.31531f
C6107 a_1828_9476# VSS 0.31531f
C6108 a_1380_9476# VSS 0.31531f
C6109 a_932_9476# VSS 0.34181f
C6110 a_21876_10664# VSS 0.34362f
C6111 a_21428_10664# VSS 0.33947f
C6112 a_20980_10664# VSS 0.34119f
C6113 a_20532_10664# VSS 0.35357f
C6114 a_19860_10664# VSS 0.38306f
C6115 a_19412_10664# VSS 0.33295f
C6116 a_18964_10664# VSS 0.33173f
C6117 a_18516_10664# VSS 0.3317f
C6118 a_18068_10664# VSS 0.33168f
C6119 a_17620_10664# VSS 0.33168f
C6120 a_17172_10664# VSS 0.33168f
C6121 a_16724_10664# VSS 0.33168f
C6122 a_16276_10664# VSS 0.34657f
C6123 a_15828_10664# VSS 0.34454f
C6124 a_15380_10664# VSS 0.34582f
C6125 a_14932_10664# VSS 0.34577f
C6126 a_14484_10664# VSS 0.34577f
C6127 a_14036_10664# VSS 0.34664f
C6128 a_13588_10664# VSS 0.34907f
C6129 a_13140_10664# VSS 0.35085f
C6130 a_12692_10664# VSS 0.36787f
C6131 a_10676_10664# VSS 0.33641f
C6132 a_10228_10664# VSS 0.33503f
C6133 a_9780_10664# VSS 0.33503f
C6134 a_9332_10664# VSS 0.33836f
C6135 a_7988_10664# VSS 0.33447f
C6136 a_7540_10664# VSS 0.33091f
C6137 a_7092_10664# VSS 0.33091f
C6138 a_6644_10664# VSS 0.33091f
C6139 a_6196_10664# VSS 0.33242f
C6140 a_5748_10664# VSS 0.33455f
C6141 a_5300_10664# VSS 0.33652f
C6142 a_4852_10664# VSS 0.35464f
C6143 a_4068_10664# VSS 0.32514f
C6144 a_3620_10664# VSS 0.31337f
C6145 a_3172_10664# VSS 0.31333f
C6146 a_2724_10664# VSS 0.31332f
C6147 a_2276_10664# VSS 0.3133f
C6148 a_1828_10664# VSS 0.3133f
C6149 a_1380_10664# VSS 0.3133f
C6150 a_932_10664# VSS 0.33989f
C6151 a_21964_10567# VSS 0.16795f
C6152 a_21516_10567# VSS 0.17002f
C6153 a_21068_10567# VSS 0.17166f
C6154 a_20620_10567# VSS 0.176f
C6155 a_19948_10567# VSS 0.23032f
C6156 a_19500_10567# VSS 0.17284f
C6157 a_19052_10567# VSS 0.16488f
C6158 a_18604_10567# VSS 0.16488f
C6159 a_18156_10567# VSS 0.16488f
C6160 a_17708_10567# VSS 0.16488f
C6161 a_17260_10567# VSS 0.16488f
C6162 a_16812_10567# VSS 0.16488f
C6163 a_16364_10567# VSS 0.16806f
C6164 a_15916_10567# VSS 0.16314f
C6165 a_15468_10567# VSS 0.16314f
C6166 a_15020_10567# VSS 0.16314f
C6167 a_14572_10567# VSS 0.16456f
C6168 a_14124_10567# VSS 0.16402f
C6169 a_13676_10567# VSS 0.17139f
C6170 a_13228_10567# VSS 0.16806f
C6171 a_12780_10567# VSS 0.17376f
C6172 a_11366_10216# VSS 0.71661f
C6173 a_10764_10567# VSS 0.126f
C6174 a_10316_10567# VSS 0.16679f
C6175 a_9868_10567# VSS 0.16704f
C6176 a_9420_10567# VSS 0.16781f
C6177 a_8792_10261# VSS 0.34115f
C6178 a_8076_10567# VSS 0.13058f
C6179 a_7628_10567# VSS 0.168f
C6180 a_7180_10567# VSS 0.16389f
C6181 a_6732_10567# VSS 0.16389f
C6182 a_6284_10567# VSS 0.1646f
C6183 a_5836_10567# VSS 0.16753f
C6184 a_5388_10567# VSS 0.16939f
C6185 a_4940_10567# VSS 0.17649f
C6186 a_4156_10567# VSS 0.16375f
C6187 a_3708_10567# VSS 0.16198f
C6188 a_3260_10567# VSS 0.16198f
C6189 a_2812_10567# VSS 0.16198f
C6190 a_2364_10567# VSS 0.16198f
C6191 a_1916_10567# VSS 0.16198f
C6192 a_1468_10567# VSS 0.16198f
C6193 a_1020_10567# VSS 0.17212f
C6194 a_22076_11000# VSS 0.18775f
C6195 a_21628_11000# VSS 0.17167f
C6196 a_21180_11000# VSS 0.17102f
C6197 a_20732_11000# VSS 0.17176f
C6198 a_20284_11000# VSS 0.17944f
C6199 a_19836_11000# VSS 0.20392f
C6200 a_19388_11000# VSS 0.16495f
C6201 a_18940_11000# VSS 0.16388f
C6202 a_18492_11000# VSS 0.16388f
C6203 a_18044_11000# VSS 0.16388f
C6204 a_17596_11000# VSS 0.16388f
C6205 a_17148_11000# VSS 0.16388f
C6206 a_16700_11000# VSS 0.16782f
C6207 a_21988_11044# VSS 0.35079f
C6208 a_21540_11044# VSS 0.33789f
C6209 a_21092_11044# VSS 0.34049f
C6210 a_20644_11044# VSS 0.3408f
C6211 a_20196_11044# VSS 0.38125f
C6212 a_19748_11044# VSS 0.34644f
C6213 a_19300_11044# VSS 0.33104f
C6214 a_18852_11044# VSS 0.33094f
C6215 a_18404_11044# VSS 0.33227f
C6216 a_17956_11044# VSS 0.3309f
C6217 a_17508_11044# VSS 0.3309f
C6218 a_17060_11044# VSS 0.3309f
C6219 a_16612_11044# VSS 0.34415f
C6220 a_15916_11000# VSS 0.15146f
C6221 a_15468_11000# VSS 0.16749f
C6222 a_15020_11000# VSS 0.16715f
C6223 a_15828_11044# VSS 0.3563f
C6224 a_15380_11044# VSS 0.35165f
C6225 a_14932_11044# VSS 0.35527f
C6226 a_12987_11161# VSS 0.35547f
C6227 a_13280_11485# VSS 0.79321f
C6228 a_11980_11529# VSS 0.20877f
C6229 a_12352_11485# VSS 0.34843f
C6230 ana_div_chain\[2\]_inv_notouch_.ZN VSS 0.56943f
C6231 a_11424_11115# VSS 1.26299f
C6232 a_11012_11528# VSS 0.7972f
C6233 ana_div_chain\[2\]_inv_notouch_.I VSS 0.67299f
C6234 a_10340_11575# VSS 0.27909f
C6235 a_9980_11000# VSS 0.11698f
C6236 a_9892_11044# VSS 0.35026f
C6237 a_8902_11472# VSS 0.69951f
C6238 a_8008_11504# VSS 0.34678f
C6239 a_7292_11000# VSS 0.13092f
C6240 a_6844_11000# VSS 0.16923f
C6241 a_6396_11000# VSS 0.16836f
C6242 a_5948_11000# VSS 0.17122f
C6243 a_5500_11000# VSS 0.17159f
C6244 a_5052_11000# VSS 0.17384f
C6245 a_4604_11000# VSS 0.20602f
C6246 a_4156_11000# VSS 0.17525f
C6247 a_3708_11000# VSS 0.16198f
C6248 a_3260_11000# VSS 0.16198f
C6249 a_2812_11000# VSS 0.16198f
C6250 a_2364_11000# VSS 0.16198f
C6251 a_1916_11000# VSS 0.16198f
C6252 a_1468_11000# VSS 0.16198f
C6253 a_1020_11000# VSS 0.17212f
C6254 a_7204_11044# VSS 0.34544f
C6255 a_6756_11044# VSS 0.33886f
C6256 a_6308_11044# VSS 0.33937f
C6257 a_5860_11044# VSS 0.3383f
C6258 a_5412_11044# VSS 0.34008f
C6259 a_4964_11044# VSS 0.34284f
C6260 a_4516_11044# VSS 0.40637f
C6261 a_4068_11044# VSS 0.32055f
C6262 a_3620_11044# VSS 0.31337f
C6263 a_3172_11044# VSS 0.31333f
C6264 a_2724_11044# VSS 0.31332f
C6265 a_2276_11044# VSS 0.3133f
C6266 a_1828_11044# VSS 0.3133f
C6267 a_1380_11044# VSS 0.3133f
C6268 a_932_11044# VSS 0.33989f
C6269 a_21876_12232# VSS 0.34362f
C6270 a_21428_12232# VSS 0.33947f
C6271 a_20980_12232# VSS 0.34119f
C6272 a_20532_12232# VSS 0.35357f
C6273 a_19860_12232# VSS 0.36937f
C6274 a_19412_12232# VSS 0.33094f
C6275 a_18964_12232# VSS 0.32972f
C6276 a_18516_12232# VSS 0.3297f
C6277 a_18068_12232# VSS 0.32967f
C6278 a_17620_12232# VSS 0.32967f
C6279 a_17172_12232# VSS 0.32967f
C6280 a_16724_12232# VSS 0.33587f
C6281 ana_div_chain\[1\]_inv_notouch_.ZN VSS 0.6081f
C6282 a_21964_12135# VSS 0.17207f
C6283 a_21516_12135# VSS 0.16886f
C6284 a_21068_12135# VSS 0.17174f
C6285 a_20620_12135# VSS 0.17419f
C6286 a_19948_12135# VSS 0.22202f
C6287 a_19500_12135# VSS 0.16877f
C6288 a_19052_12135# VSS 0.16224f
C6289 a_18604_12135# VSS 0.16414f
C6290 a_18156_12135# VSS 0.16535f
C6291 a_17708_12135# VSS 0.16535f
C6292 a_17260_12135# VSS 0.16535f
C6293 a_16812_12135# VSS 0.16535f
C6294 a_14776_11919# VSS 0.307f
C6295 a_14880_11875# VSS 0.18574f
C6296 a_14392_12243# VSS 1.23772f
C6297 a_14432_11875# VSS 0.79742f
C6298 a_13988_12071# VSS 0.34677f
C6299 wire18.I VSS 1.61172f
C6300 a_13384_11784# VSS 0.79149f
C6301 a_11478_11784# VSS 0.74429f
C6302 a_10032_11875# VSS 0.78052f
C6303 a_9739_12287# VSS 0.3572f
C6304 a_8732_11919# VSS 0.18006f
C6305 a_9104_11875# VSS 0.30117f
C6306 a_8176_12232# VSS 1.22586f
C6307 dac_div_chain\[2\]_load_slew15.Z VSS 0.4824f
C6308 a_7092_12232# VSS 0.34415f
C6309 a_6644_12232# VSS 0.34014f
C6310 a_6196_12232# VSS 0.3378f
C6311 a_5748_12232# VSS 0.33992f
C6312 a_5300_12232# VSS 0.3419f
C6313 a_4852_12232# VSS 0.35978f
C6314 a_4068_12232# VSS 0.32514f
C6315 a_3620_12232# VSS 0.31337f
C6316 a_3172_12232# VSS 0.31333f
C6317 a_2724_12232# VSS 0.31332f
C6318 a_2276_12232# VSS 0.3133f
C6319 a_1828_12232# VSS 0.3133f
C6320 a_1380_12232# VSS 0.3133f
C6321 a_932_12232# VSS 0.33989f
C6322 a_7764_11911# VSS 0.78242f
C6323 a_7180_12135# VSS 0.13489f
C6324 a_6732_12135# VSS 0.16851f
C6325 a_6284_12135# VSS 0.1688f
C6326 a_5836_12135# VSS 0.17043f
C6327 a_5388_12135# VSS 0.17228f
C6328 a_4940_12135# VSS 0.17884f
C6329 a_4156_12135# VSS 0.16375f
C6330 a_3708_12135# VSS 0.16198f
C6331 a_3260_12135# VSS 0.16198f
C6332 a_2812_12135# VSS 0.16198f
C6333 a_2364_12135# VSS 0.16198f
C6334 a_1916_12135# VSS 0.16198f
C6335 a_1468_12135# VSS 0.16198f
C6336 a_1020_12135# VSS 0.17212f
C6337 a_20603_12729# VSS 0.35498f
C6338 a_20896_13053# VSS 0.79452f
C6339 a_19596_13097# VSS 0.21742f
C6340 a_19968_13053# VSS 0.34603f
C6341 a_19040_12683# VSS 1.25689f
C6342 a_18628_13096# VSS 0.79729f
C6343 a_18044_12568# VSS 0.13446f
C6344 a_17596_12568# VSS 0.16677f
C6345 a_17148_12568# VSS 0.16677f
C6346 a_16700_12568# VSS 0.17018f
C6347 a_17956_12612# VSS 0.32266f
C6348 a_17508_12612# VSS 0.31866f
C6349 a_17060_12612# VSS 0.31866f
C6350 a_16612_12612# VSS 0.33167f
C6351 a_15916_12568# VSS 0.15197f
C6352 dac_div_chain\[1\]_inv_notouch_.ZN VSS 0.37453f
C6353 a_12536_13097# VSS 0.31671f
C6354 a_12640_12932# VSS 0.1926f
C6355 a_12152_12637# VSS 1.2834f
C6356 a_12192_13053# VSS 0.81594f
C6357 a_15828_12612# VSS 0.35993f
C6358 a_14708_12612# VSS 0.65925f
C6359 a_11748_12568# VSS 0.39007f
C6360 ana_div_chain\[2\]_dff_notouch_.CLK VSS 0.59102f
C6361 a_10340_13143# VSS 0.28704f
C6362 a_9980_12568# VSS 0.11387f
C6363 a_11144_12971# VSS 0.80156f
C6364 a_9892_12612# VSS 0.35795f
C6365 dac_div_chain\[1\]_inv_notouch_.I VSS 1.36465f
C6366 a_8902_13040# VSS 0.69762f
C6367 dac_div_chain\[2\]_dff_notouch_.D VSS 0.38717f
C6368 a_7740_12568# VSS 0.17765f
C6369 a_7292_12568# VSS 0.16488f
C6370 a_6844_12568# VSS 0.16488f
C6371 a_6396_12568# VSS 0.16488f
C6372 a_5948_12568# VSS 0.16818f
C6373 a_5500_12568# VSS 0.16985f
C6374 a_5052_12568# VSS 0.1721f
C6375 a_4604_12568# VSS 0.2043f
C6376 a_4156_12568# VSS 0.17427f
C6377 a_3708_12568# VSS 0.16314f
C6378 a_3260_12568# VSS 0.16314f
C6379 a_2812_12568# VSS 0.16314f
C6380 a_2364_12568# VSS 0.16314f
C6381 a_1916_12568# VSS 0.16314f
C6382 a_1468_12568# VSS 0.16314f
C6383 a_1020_12568# VSS 0.17306f
C6384 dac_div_chain\[2\]_load_slew11.Z VSS 0.71345f
C6385 a_7652_12612# VSS 0.33168f
C6386 a_7204_12612# VSS 0.33168f
C6387 a_6756_12612# VSS 0.33168f
C6388 a_6308_12612# VSS 0.33219f
C6389 a_5860_12612# VSS 0.33495f
C6390 a_5412_12612# VSS 0.33673f
C6391 a_4964_12612# VSS 0.33949f
C6392 a_4516_12612# VSS 0.40303f
C6393 a_4068_12612# VSS 0.32255f
C6394 a_3620_12612# VSS 0.31538f
C6395 a_3172_12612# VSS 0.31534f
C6396 a_2724_12612# VSS 0.31532f
C6397 a_2276_12612# VSS 0.31531f
C6398 a_1828_12612# VSS 0.31531f
C6399 a_1380_12612# VSS 0.31531f
C6400 a_932_12612# VSS 0.34181f
C6401 a_21652_13800# VSS 0.34629f
C6402 ana_div_chain\[0\]_dff_notouch_.D VSS 0.47967f
C6403 a_18404_13800# VSS 0.35853f
C6404 a_17956_13800# VSS 0.31866f
C6405 a_17508_13800# VSS 0.31866f
C6406 a_17060_13800# VSS 0.31866f
C6407 a_16612_13800# VSS 0.32486f
C6408 a_21740_13703# VSS 0.1628f
C6409 ana_div_chain\[0\]_dff_notouch_.Q VSS 0.83749f
C6410 a_20662_13352# VSS 0.70218f
C6411 a_19768_13397# VSS 0.38332f
C6412 ana_div_chain\[1\]_dff_notouch_.CLK VSS 1.38257f
C6413 a_18492_13703# VSS 0.1457f
C6414 a_18044_13703# VSS 0.16705f
C6415 a_17596_13703# VSS 0.16488f
C6416 a_17148_13703# VSS 0.16488f
C6417 a_16700_13703# VSS 0.16488f
C6418 a_14664_13487# VSS 0.30112f
C6419 a_14768_13443# VSS 0.17762f
C6420 a_14280_13811# VSS 1.23085f
C6421 a_14320_13443# VSS 0.80216f
C6422 a_13876_13639# VSS 0.35857f
C6423 wire20.I VSS 0.86691f
C6424 a_12692_13800# VSS 0.37774f
C6425 a_13272_13352# VSS 0.80571f
C6426 a_12780_13703# VSS 0.16104f
C6427 a_11264_13443# VSS 0.81052f
C6428 a_10971_13855# VSS 0.35984f
C6429 a_9964_13487# VSS 0.18239f
C6430 a_10336_13443# VSS 0.30672f
C6431 a_9408_13800# VSS 1.23843f
C6432 wire12.I VSS 1.34818f
C6433 a_8436_13800# VSS 0.3601f
C6434 a_7988_13800# VSS 0.33102f
C6435 a_7540_13800# VSS 0.33226f
C6436 a_7092_13800# VSS 0.33091f
C6437 a_6644_13800# VSS 0.33091f
C6438 a_6196_13800# VSS 0.33242f
C6439 a_5748_13800# VSS 0.33455f
C6440 a_5300_13800# VSS 0.33652f
C6441 a_4852_13800# VSS 0.35464f
C6442 a_4068_13800# VSS 0.32514f
C6443 a_3620_13800# VSS 0.31337f
C6444 a_3172_13800# VSS 0.31333f
C6445 a_2724_13800# VSS 0.31332f
C6446 a_2276_13800# VSS 0.3133f
C6447 a_1828_13800# VSS 0.3133f
C6448 a_1380_13800# VSS 0.3133f
C6449 a_932_13800# VSS 0.33989f
C6450 a_8996_13479# VSS 0.77105f
C6451 a_8524_13703# VSS 0.13238f
C6452 a_8076_13703# VSS 0.16824f
C6453 a_7628_13703# VSS 0.16388f
C6454 a_7180_13703# VSS 0.16388f
C6455 a_6732_13703# VSS 0.16388f
C6456 a_6284_13703# VSS 0.1646f
C6457 a_5836_13703# VSS 0.16753f
C6458 a_5388_13703# VSS 0.16938f
C6459 a_4940_13703# VSS 0.17649f
C6460 a_4156_13703# VSS 0.16375f
C6461 a_3708_13703# VSS 0.16198f
C6462 a_3260_13703# VSS 0.16198f
C6463 a_2812_13703# VSS 0.16198f
C6464 a_2364_13703# VSS 0.16198f
C6465 a_1916_13703# VSS 0.16198f
C6466 a_1468_13703# VSS 0.16198f
C6467 a_1020_13703# VSS 0.17212f
C6468 a_21852_14136# VSS 0.16402f
C6469 a_21404_14136# VSS 0.16976f
C6470 a_19836_14136# VSS 0.16739f
C6471 a_19388_14136# VSS 0.1668f
C6472 a_18940_14136# VSS 0.1659f
C6473 a_18492_14136# VSS 0.16198f
C6474 a_18044_14136# VSS 0.16198f
C6475 a_17596_14136# VSS 0.16198f
C6476 a_17148_14136# VSS 0.16198f
C6477 a_16700_14136# VSS 0.16611f
C6478 a_21764_14180# VSS 0.34714f
C6479 a_21316_14180# VSS 0.34404f
C6480 a_20420_14180# VSS 0.47836f
C6481 input1.Z VSS 3.57712f
C6482 a_19748_14180# VSS 0.34843f
C6483 a_19300_14180# VSS 0.33005f
C6484 a_18852_14180# VSS 0.33f
C6485 a_18404_14180# VSS 0.32998f
C6486 a_17956_14180# VSS 0.32996f
C6487 a_17508_14180# VSS 0.32996f
C6488 a_17060_14180# VSS 0.33903f
C6489 a_16612_14180# VSS 0.35104f
C6490 a_14728_14640# VSS 0.30871f
C6491 dac_div_chain\[0\]_inv_notouch_.ZN VSS 0.45616f
C6492 a_13116_14136# VSS 0.1588f
C6493 a_12668_14136# VSS 0.17746f
C6494 a_12220_14136# VSS 0.23684f
C6495 a_11772_14136# VSS 0.17265f
C6496 a_11324_14136# VSS 0.16955f
C6497 dac_div_chain\[3\]_inv_notouch_.ZN VSS 0.44682f
C6498 a_10204_14136# VSS 0.12944f
C6499 a_9756_14136# VSS 0.1651f
C6500 a_9308_14136# VSS 0.16501f
C6501 a_8860_14136# VSS 0.17199f
C6502 input2.Z VSS 2.97526f
C6503 a_15398_14516# VSS 0.5036f
C6504 dac_div_chain\[1\]_dff_notouch_.CLK VSS 0.82704f
C6505 a_13028_14180# VSS 0.35061f
C6506 a_12580_14180# VSS 0.3459f
C6507 a_12132_14180# VSS 0.38152f
C6508 a_11684_14180# VSS 0.33816f
C6509 a_11236_14180# VSS 0.33819f
C6510 a_10116_14180# VSS 0.33891f
C6511 a_9668_14180# VSS 0.33627f
C6512 a_9220_14180# VSS 0.33627f
C6513 a_8772_14180# VSS 0.34674f
C6514 a_8188_14136# VSS 0.17107f
C6515 a_7740_14136# VSS 0.16836f
C6516 a_7292_14136# VSS 0.16488f
C6517 a_6844_14136# VSS 0.16488f
C6518 a_6396_14136# VSS 0.16488f
C6519 a_5948_14136# VSS 0.16818f
C6520 a_5500_14136# VSS 0.16985f
C6521 a_5052_14136# VSS 0.1721f
C6522 a_4604_14136# VSS 0.2043f
C6523 a_4156_14136# VSS 0.17427f
C6524 a_3708_14136# VSS 0.16314f
C6525 a_3260_14136# VSS 0.16314f
C6526 a_2812_14136# VSS 0.16314f
C6527 a_2364_14136# VSS 0.16314f
C6528 a_1916_14136# VSS 0.16314f
C6529 a_1468_14136# VSS 0.16314f
C6530 a_1020_14136# VSS 0.17306f
C6531 a_8100_14180# VSS 0.34558f
C6532 a_7652_14180# VSS 0.33168f
C6533 a_7204_14180# VSS 0.33168f
C6534 a_6756_14180# VSS 0.33168f
C6535 a_6308_14180# VSS 0.33219f
C6536 a_5860_14180# VSS 0.33495f
C6537 a_5412_14180# VSS 0.33673f
C6538 a_4964_14180# VSS 0.33949f
C6539 a_4516_14180# VSS 0.40303f
C6540 a_4068_14180# VSS 0.32255f
C6541 a_3620_14180# VSS 0.31538f
C6542 a_3172_14180# VSS 0.31534f
C6543 a_2724_14180# VSS 0.31532f
C6544 a_2276_14180# VSS 0.31531f
C6545 a_1828_14180# VSS 0.31531f
C6546 a_1380_14180# VSS 0.31531f
C6547 a_932_14180# VSS 0.34181f
C6548 a_21876_15368# VSS 0.34342f
C6549 a_21428_15368# VSS 0.33641f
C6550 a_20980_15368# VSS 0.34292f
C6551 a_20532_15368# VSS 0.35819f
C6552 a_19636_15368# VSS 0.35367f
C6553 a_19188_15368# VSS 0.34142f
C6554 a_18740_15368# VSS 0.33764f
C6555 a_18292_15368# VSS 0.33766f
C6556 a_17844_15368# VSS 0.33764f
C6557 a_17396_15368# VSS 0.34206f
C6558 a_21964_15271# VSS 0.16914f
C6559 a_21516_15271# VSS 0.16815f
C6560 a_21068_15271# VSS 0.16815f
C6561 a_20620_15271# VSS 0.17264f
C6562 a_19724_15271# VSS 0.16968f
C6563 a_19276_15271# VSS 0.17289f
C6564 a_18828_15271# VSS 0.17008f
C6565 a_18380_15271# VSS 0.16963f
C6566 a_17932_15271# VSS 0.16892f
C6567 a_17484_15271# VSS 0.16998f
C6568 a_16192_15011# VSS 0.79235f
C6569 a_15899_15423# VSS 0.35986f
C6570 a_14892_15055# VSS 0.17883f
C6571 a_15264_15011# VSS 0.30892f
C6572 ana_div_chain\[3\]_inv_notouch_.ZN VSS 0.45822f
C6573 a_14336_15368# VSS 1.23521f
C6574 ana_div_chain\[2\]_dff_notouch_.Q VSS 1.62744f
C6575 a_13140_15368# VSS 0.34854f
C6576 a_12692_15368# VSS 0.35794f
C6577 a_12020_15368# VSS 0.37081f
C6578 a_11572_15368# VSS 0.33438f
C6579 a_11124_15368# VSS 0.33311f
C6580 a_10676_15368# VSS 0.34337f
C6581 a_10228_15368# VSS 0.33168f
C6582 a_9780_15368# VSS 0.33251f
C6583 a_9332_15368# VSS 0.3317f
C6584 a_8884_15368# VSS 0.33198f
C6585 a_8436_15368# VSS 0.34657f
C6586 a_7988_15368# VSS 0.33296f
C6587 a_7540_15368# VSS 0.33292f
C6588 a_7092_15368# VSS 0.33292f
C6589 a_6644_15368# VSS 0.33292f
C6590 a_6196_15368# VSS 0.33442f
C6591 a_5748_15368# VSS 0.33656f
C6592 a_5300_15368# VSS 0.33853f
C6593 a_4852_15368# VSS 0.35655f
C6594 a_4068_15368# VSS 0.32514f
C6595 a_3620_15368# VSS 0.31337f
C6596 a_3172_15368# VSS 0.31333f
C6597 a_2724_15368# VSS 0.31332f
C6598 a_2276_15368# VSS 0.3133f
C6599 a_1828_15368# VSS 0.3133f
C6600 a_1380_15368# VSS 0.3133f
C6601 a_932_15368# VSS 0.33989f
C6602 a_13924_15047# VSS 0.78407f
C6603 a_13228_15271# VSS 0.14373f
C6604 a_12780_15271# VSS 0.17743f
C6605 a_12108_15271# VSS 0.2139f
C6606 a_11660_15271# VSS 0.16937f
C6607 a_11212_15271# VSS 0.16327f
C6608 a_10764_15271# VSS 0.16624f
C6609 a_10316_15271# VSS 0.16488f
C6610 a_9868_15271# VSS 0.16488f
C6611 a_9420_15271# VSS 0.16488f
C6612 a_8972_15271# VSS 0.16488f
C6613 a_8524_15271# VSS 0.16653f
C6614 a_8076_15271# VSS 0.16505f
C6615 a_7628_15271# VSS 0.16504f
C6616 a_7180_15271# VSS 0.16504f
C6617 a_6732_15271# VSS 0.16504f
C6618 a_6284_15271# VSS 0.16575f
C6619 a_5836_15271# VSS 0.16869f
C6620 a_5388_15271# VSS 0.17054f
C6621 a_4940_15271# VSS 0.17743f
C6622 a_4156_15271# VSS 0.16375f
C6623 a_3708_15271# VSS 0.16198f
C6624 a_3260_15271# VSS 0.16198f
C6625 a_2812_15271# VSS 0.16198f
C6626 a_2364_15271# VSS 0.16198f
C6627 a_1916_15271# VSS 0.16198f
C6628 a_1468_15271# VSS 0.16198f
C6629 a_1020_15271# VSS 0.17212f
C6630 a_21740_15704# VSS 0.16298f
C6631 a_21292_15704# VSS 0.1716f
C6632 a_20844_15704# VSS 0.16924f
C6633 a_20396_15704# VSS 0.16788f
C6634 a_19948_15704# VSS 0.22876f
C6635 a_19500_15704# VSS 0.17145f
C6636 a_19052_15704# VSS 0.16688f
C6637 a_18604_15704# VSS 0.16688f
C6638 a_18156_15704# VSS 0.16688f
C6639 a_17708_15704# VSS 0.16976f
C6640 a_16700_15704# VSS 0.13041f
C6641 a_21652_15748# VSS 0.3609f
C6642 a_21204_15748# VSS 0.35433f
C6643 a_20756_15748# VSS 0.34521f
C6644 a_20308_15748# VSS 0.35239f
C6645 a_19860_15748# VSS 0.34981f
C6646 a_19412_15748# VSS 0.31457f
C6647 a_18964_15748# VSS 0.32573f
C6648 a_18516_15748# VSS 0.34425f
C6649 a_18068_15748# VSS 0.33571f
C6650 a_17620_15748# VSS 0.34062f
C6651 a_16612_15748# VSS 0.36258f
C6652 a_15804_15704# VSS 0.1472f
C6653 a_15356_15704# VSS 0.16488f
C6654 a_14908_15704# VSS 0.16892f
C6655 a_14460_15704# VSS 0.16594f
C6656 a_15716_15748# VSS 0.35289f
C6657 a_15268_15748# VSS 0.3363f
C6658 a_14820_15748# VSS 0.3363f
C6659 a_14372_15748# VSS 0.3407f
C6660 a_12875_15865# VSS 0.36843f
C6661 a_13168_16189# VSS 0.7932f
C6662 a_11868_16233# VSS 0.21224f
C6663 a_12240_16189# VSS 0.3428f
C6664 a_11312_15819# VSS 1.26115f
C6665 a_10900_16232# VSS 0.80242f
C6666 a_10204_15704# VSS 0.13809f
C6667 a_9756_15704# VSS 0.16678f
C6668 a_9308_15704# VSS 0.16678f
C6669 a_8860_15704# VSS 0.16996f
C6670 a_10116_15748# VSS 0.34069f
C6671 a_9668_15748# VSS 0.33628f
C6672 a_9220_15748# VSS 0.33628f
C6673 a_8772_15748# VSS 0.34675f
C6674 a_8188_15704# VSS 0.16991f
C6675 a_7740_15704# VSS 0.16836f
C6676 a_7292_15704# VSS 0.16488f
C6677 a_6844_15704# VSS 0.16488f
C6678 a_6396_15704# VSS 0.16488f
C6679 a_5948_15704# VSS 0.16818f
C6680 a_5500_15704# VSS 0.16985f
C6681 a_5052_15704# VSS 0.1721f
C6682 a_4604_15704# VSS 0.2043f
C6683 a_4156_15704# VSS 0.17427f
C6684 a_3708_15704# VSS 0.16314f
C6685 a_3260_15704# VSS 0.16314f
C6686 a_2812_15704# VSS 0.16314f
C6687 a_2364_15704# VSS 0.16314f
C6688 a_1916_15704# VSS 0.16314f
C6689 a_1468_15704# VSS 0.16314f
C6690 a_1020_15704# VSS 0.17306f
C6691 a_8100_15748# VSS 0.34558f
C6692 a_7652_15748# VSS 0.33168f
C6693 a_7204_15748# VSS 0.33168f
C6694 a_6756_15748# VSS 0.33168f
C6695 a_6308_15748# VSS 0.33219f
C6696 a_5860_15748# VSS 0.33495f
C6697 a_5412_15748# VSS 0.33673f
C6698 a_4964_15748# VSS 0.33949f
C6699 a_4516_15748# VSS 0.40303f
C6700 a_4068_15748# VSS 0.32255f
C6701 a_3620_15748# VSS 0.31538f
C6702 a_3172_15748# VSS 0.31534f
C6703 a_2724_15748# VSS 0.31532f
C6704 a_2276_15748# VSS 0.31531f
C6705 a_1828_15748# VSS 0.31531f
C6706 a_1380_15748# VSS 0.31531f
C6707 a_932_15748# VSS 0.34181f
C6708 a_21876_16936# VSS 0.35493f
C6709 a_21428_16936# VSS 0.34916f
C6710 a_20980_16936# VSS 0.34916f
C6711 a_20532_16936# VSS 0.36038f
C6712 a_19860_16936# VSS 0.36283f
C6713 a_19412_16936# VSS 0.32818f
C6714 a_21964_16839# VSS 0.16828f
C6715 a_21516_16839# VSS 0.16712f
C6716 a_21068_16839# VSS 0.16712f
C6717 a_20620_16839# VSS 0.17063f
C6718 a_19948_16839# VSS 0.23055f
C6719 a_19500_16839# VSS 0.17526f
C6720 a_18208_16579# VSS 0.77046f
C6721 a_17915_16991# VSS 0.35784f
C6722 a_16908_16623# VSS 0.18537f
C6723 a_17280_16579# VSS 0.30446f
C6724 ana_div_chain\[4\]_inv_notouch_.ZN VSS 0.41155f
C6725 a_16352_16936# VSS 1.22884f
C6726 a_15380_16936# VSS 0.34225f
C6727 a_14932_16936# VSS 0.33887f
C6728 a_14484_16936# VSS 0.33508f
C6729 a_14036_16936# VSS 0.34356f
C6730 a_13588_16936# VSS 0.3452f
C6731 a_13140_16936# VSS 0.35236f
C6732 dac_div_chain\[4\]_dff_notouch_.D VSS 0.83375f
C6733 dac_div_chain\[4\]_dff_notouch_.CLK VSS 0.47366f
C6734 a_10676_16936# VSS 0.35453f
C6735 a_10228_16936# VSS 0.33886f
C6736 a_9780_16936# VSS 0.33503f
C6737 a_9332_16936# VSS 0.33503f
C6738 a_8884_16936# VSS 0.33503f
C6739 a_8436_16936# VSS 0.34992f
C6740 a_7988_16936# VSS 0.33095f
C6741 a_7540_16936# VSS 0.33091f
C6742 a_7092_16936# VSS 0.33091f
C6743 a_6644_16936# VSS 0.33091f
C6744 a_6196_16936# VSS 0.33242f
C6745 a_5748_16936# VSS 0.33455f
C6746 a_5300_16936# VSS 0.33652f
C6747 a_4852_16936# VSS 0.35464f
C6748 a_4068_16936# VSS 0.32514f
C6749 a_3620_16936# VSS 0.31337f
C6750 a_3172_16936# VSS 0.31333f
C6751 a_2724_16936# VSS 0.31332f
C6752 a_2276_16936# VSS 0.3133f
C6753 a_1828_16936# VSS 0.3133f
C6754 a_1380_16936# VSS 0.3133f
C6755 a_932_16936# VSS 0.33989f
C6756 a_15940_16615# VSS 0.78544f
C6757 a_15468_16839# VSS 0.13078f
C6758 a_15020_16839# VSS 0.16871f
C6759 a_14572_16839# VSS 0.16827f
C6760 a_14124_16839# VSS 0.16697f
C6761 a_13676_16839# VSS 0.16762f
C6762 a_13228_16839# VSS 0.17032f
C6763 dac_div_chain\[4\]_inv_notouch_.I VSS 0.63605f
C6764 a_11796_16577# VSS 0.3034f
C6765 a_11256_16533# VSS 0.28756f
C6766 a_10764_16839# VSS 0.1195f
C6767 a_10316_16839# VSS 0.16985f
C6768 a_9868_16839# VSS 0.16792f
C6769 a_9420_16839# VSS 0.16662f
C6770 a_8972_16839# VSS 0.16663f
C6771 a_8524_16839# VSS 0.17118f
C6772 a_8076_16839# VSS 0.16641f
C6773 a_7628_16839# VSS 0.16424f
C6774 a_7180_16839# VSS 0.16551f
C6775 a_6732_16839# VSS 0.16551f
C6776 a_6284_16839# VSS 0.16632f
C6777 a_5836_16839# VSS 0.16916f
C6778 a_5388_16839# VSS 0.16973f
C6779 a_4940_16839# VSS 0.17685f
C6780 a_4156_16839# VSS 0.16375f
C6781 a_3708_16839# VSS 0.16198f
C6782 a_3260_16839# VSS 0.16198f
C6783 a_2812_16839# VSS 0.16198f
C6784 a_2364_16839# VSS 0.16198f
C6785 a_1916_16839# VSS 0.16198f
C6786 a_1468_16839# VSS 0.16198f
C6787 a_1020_16839# VSS 0.17212f
C6788 a_22076_17272# VSS 0.18794f
C6789 a_21628_17272# VSS 0.16407f
C6790 a_21180_17272# VSS 0.16407f
C6791 a_20732_17272# VSS 0.16407f
C6792 a_20284_17272# VSS 0.17377f
C6793 a_19836_17272# VSS 0.20348f
C6794 a_19388_17272# VSS 0.16667f
C6795 a_18940_17272# VSS 0.16198f
C6796 ana_div_chain\[4\]_dff_notouch_.CLK VSS 0.4241f
C6797 a_21988_17316# VSS 0.35347f
C6798 a_21540_17316# VSS 0.34709f
C6799 a_21092_17316# VSS 0.34708f
C6800 a_20644_17316# VSS 0.34725f
C6801 a_20196_17316# VSS 0.37661f
C6802 a_19748_17316# VSS 0.36341f
C6803 a_19300_17316# VSS 0.33158f
C6804 a_18852_17316# VSS 0.33153f
C6805 ana_div_chain\[4\]_dff_notouch_.Q VSS 0.70329f
C6806 a_17862_17744# VSS 0.69451f
C6807 a_16612_17316# VSS 0.69281f
C6808 ana_div_chain\[3\]_inv_notouch_.I VSS 1.43927f
C6809 a_15848_17776# VSS 0.34643f
C6810 a_15356_17272# VSS 0.11795f
C6811 a_14908_17272# VSS 0.16852f
C6812 a_14460_17272# VSS 0.16809f
C6813 a_14012_17272# VSS 0.16695f
C6814 a_13564_17272# VSS 0.16841f
C6815 a_13116_17272# VSS 0.16757f
C6816 a_10204_17272# VSS 0.12852f
C6817 a_9756_17272# VSS 0.16678f
C6818 a_9308_17272# VSS 0.16678f
C6819 a_8860_17272# VSS 0.16996f
C6820 a_15268_17316# VSS 0.35833f
C6821 a_14820_17316# VSS 0.35621f
C6822 a_14372_17316# VSS 0.35237f
C6823 a_13924_17316# VSS 0.35238f
C6824 a_13476_17316# VSS 0.3524f
C6825 a_13028_17316# VSS 0.35502f
C6826 dac_div_chain\[4\]_dff_notouch_.Q VSS 1.03844f
C6827 a_12038_17744# VSS 0.76991f
C6828 a_10788_17316# VSS 0.65653f
C6829 dac_div_chain\[3\]_inv_notouch_.I VSS 1.54326f
C6830 a_10116_17316# VSS 0.35314f
C6831 a_9668_17316# VSS 0.33812f
C6832 a_9220_17316# VSS 0.33812f
C6833 a_8772_17316# VSS 0.36015f
C6834 a_8188_17272# VSS 0.16991f
C6835 a_7740_17272# VSS 0.16836f
C6836 a_7292_17272# VSS 0.16488f
C6837 a_6844_17272# VSS 0.16488f
C6838 a_6396_17272# VSS 0.16488f
C6839 a_5948_17272# VSS 0.16818f
C6840 a_5500_17272# VSS 0.16985f
C6841 a_5052_17272# VSS 0.1721f
C6842 a_4604_17272# VSS 0.2043f
C6843 a_4156_17272# VSS 0.17427f
C6844 a_3708_17272# VSS 0.16314f
C6845 a_3260_17272# VSS 0.16314f
C6846 a_2812_17272# VSS 0.16314f
C6847 a_2364_17272# VSS 0.16314f
C6848 a_1916_17272# VSS 0.16314f
C6849 a_1468_17272# VSS 0.16314f
C6850 a_1020_17272# VSS 0.17306f
C6851 a_8100_17316# VSS 0.36236f
C6852 a_7652_17316# VSS 0.35043f
C6853 a_7204_17316# VSS 0.34779f
C6854 a_6756_17316# VSS 0.33477f
C6855 a_6308_17316# VSS 0.33528f
C6856 a_5860_17316# VSS 0.3496f
C6857 a_5412_17316# VSS 0.35284f
C6858 a_4964_17316# VSS 0.35824f
C6859 a_4516_17316# VSS 0.40538f
C6860 a_4068_17316# VSS 0.34075f
C6861 a_3620_17316# VSS 0.33357f
C6862 a_3172_17316# VSS 0.33504f
C6863 a_2724_17316# VSS 0.34781f
C6864 a_2276_17316# VSS 0.34907f
C6865 a_1828_17316# VSS 0.35042f
C6866 a_1380_17316# VSS 0.34779f
C6867 a_932_17316# VSS 0.3548f
C6868 a_21764_18504# VSS 0.36396f
C6869 a_21316_18504# VSS 0.35053f
C6870 a_20868_18504# VSS 0.35056f
C6871 a_20420_18504# VSS 0.35145f
C6872 a_19972_18504# VSS 0.41971f
C6873 a_19188_18504# VSS 0.34833f
C6874 a_18740_18504# VSS 0.34042f
C6875 a_18292_18504# VSS 0.34837f
C6876 ana_div_chain\[4\]_inv_notouch_.I VSS 0.74739f
C6877 a_17060_18504# VSS 0.34005f
C6878 a_16612_18504# VSS 0.33465f
C6879 a_16164_18504# VSS 0.36273f
C6880 a_15492_18504# VSS 0.34771f
C6881 a_15044_18504# VSS 0.34515f
C6882 a_14596_18504# VSS 0.34515f
C6883 a_14148_18504# VSS 0.34514f
C6884 a_13700_18504# VSS 0.34516f
C6885 a_13252_18504# VSS 0.34518f
C6886 a_12804_18504# VSS 0.3525f
C6887 a_12356_18504# VSS 0.37606f
C6888 a_11684_18504# VSS 0.36238f
C6889 a_11236_18504# VSS 0.33425f
C6890 a_10788_18504# VSS 0.34053f
C6891 a_9780_18504# VSS 0.34058f
C6892 a_9332_18504# VSS 0.34464f
C6893 a_7876_18504# VSS 0.36819f
C6894 a_6868_18504# VSS 0.34197f
C6895 a_6420_18504# VSS 0.3457f
C6896 a_5188_18504# VSS 0.37316f
C6897 a_3956_18504# VSS 0.35006f
C6898 a_3508_18504# VSS 0.34647f
C6899 a_2500_18504# VSS 0.35713f
C6900 a_2052_18504# VSS 0.36334f
C6901 a_21852_18407# VSS 0.1831f
C6902 a_21404_18407# VSS 0.18926f
C6903 a_20956_18407# VSS 0.18708f
C6904 a_20508_18407# VSS 0.18713f
C6905 a_20060_18407# VSS 0.236f
C6906 a_19276_18407# VSS 0.17403f
C6907 a_18828_18407# VSS 0.18969f
C6908 a_18380_18407# VSS 0.18885f
C6909 a_17752_18101# VSS 0.35286f
C6910 a_17148_18407# VSS 0.14591f
C6911 a_16700_18407# VSS 0.18969f
C6912 a_16252_18407# VSS 0.19168f
C6913 a_15580_18407# VSS 0.18893f
C6914 a_15132_18407# VSS 0.18418f
C6915 a_14684_18407# VSS 0.18418f
C6916 a_14236_18407# VSS 0.18418f
C6917 a_13788_18407# VSS 0.18418f
C6918 a_13340_18407# VSS 0.18418f
C6919 a_12892_18407# VSS 0.18995f
C6920 a_12444_18407# VSS 0.209f
C6921 a_11772_18407# VSS 0.19585f
C6922 a_11324_18407# VSS 0.18969f
C6923 a_10876_18407# VSS 0.1909f
C6924 a_10419_18100# VSS 0.3466f
C6925 a_9868_18407# VSS 0.14827f
C6926 a_9420_18407# VSS 0.1909f
C6927 a_8963_18100# VSS 0.36596f
C6928 a_7964_18407# VSS 0.19774f
C6929 a_7507_18100# VSS 0.34639f
C6930 a_6956_18407# VSS 0.14827f
C6931 a_6508_18407# VSS 0.1909f
C6932 a_6051_18100# VSS 0.35627f
C6933 a_5276_18407# VSS 0.16463f
C6934 a_4819_18100# VSS 0.38925f
C6935 a_4044_18407# VSS 0.18559f
C6936 a_3596_18407# VSS 0.1909f
C6937 a_3139_18100# VSS 0.33278f
C6938 a_2588_18407# VSS 0.14827f
C6939 a_2140_18407# VSS 0.1909f
C6940 a_1683_18100# VSS 0.36742f
C6941 a_1011_18100# VSS 0.37904f
C6942 VDD.t487 VSS 0.39196f
C6943 VDD.t289 VSS 0.70159f
C6944 VDD.t1853 VSS 0.03468f
C6945 VDD.t290 VSS 0.03305f
C6946 VDD.t243 VSS 0.03468f
C6947 VDD.t711 VSS 0.03305f
C6948 VDD.t886 VSS 0.03468f
C6949 VDD.t7 VSS 0.03305f
C6950 VDD.t465 VSS 0.03468f
C6951 VDD.t230 VSS 0.03305f
C6952 VDD.t256 VSS 0.03468f
C6953 VDD.t749 VSS 0.03305f
C6954 VDD.t1 VSS 0.03468f
C6955 VDD.t329 VSS 0.03305f
C6956 VDD.t298 VSS 0.03468f
C6957 VDD.t1870 VSS 0.03305f
C6958 VDD.t489 VSS 0.03468f
C6959 VDD.t285 VSS 0.03305f
C6960 VDD.t242 VSS 0.80181f
C6961 VDD.t6 VSS 0.80181f
C6962 VDD.t229 VSS 0.80181f
C6963 VDD.t255 VSS 0.80181f
C6964 VDD.t0 VSS 0.80181f
C6965 VDD.t297 VSS 0.80181f
C6966 VDD.t284 VSS 0.59241f
C6967 VDD.n10 VSS 0.48696f
C6968 VDD.n17 VSS 1.07521f
C6969 VDD.t783 VSS 0.03468f
C6970 VDD.t878 VSS 0.03305f
C6971 VDD.t1032 VSS 0.03468f
C6972 VDD.t249 VSS 0.03305f
C6973 VDD.t1550 VSS 0.03468f
C6974 VDD.t390 VSS 0.03305f
C6975 VDD.t374 VSS 0.03468f
C6976 VDD.t484 VSS 0.03305f
C6977 VDD.t2022 VSS 0.03468f
C6978 VDD.t424 VSS 0.03305f
C6979 VDD.t631 VSS 0.03468f
C6980 VDD.t247 VSS 0.03305f
C6981 VDD.t757 VSS 0.03468f
C6982 VDD.t486 VSS 0.03305f
C6983 VDD.t1180 VSS 0.03468f
C6984 VDD.t1820 VSS 0.03305f
C6985 VDD.t517 VSS 0.03468f
C6986 VDD.t9 VSS 0.03305f
C6987 VDD.t2102 VSS 0.03468f
C6988 VDD.t1221 VSS 0.03305f
C6989 VDD.t499 VSS 0.03468f
C6990 VDD.t718 VSS 0.03305f
C6991 VDD.t1549 VSS 0.03468f
C6992 VDD.t883 VSS 0.03305f
C6993 VDD.t2004 VSS 0.03468f
C6994 VDD.t15 VSS 0.03305f
C6995 VDD.t1950 VSS 0.03468f
C6996 VDD.t71 VSS 0.03305f
C6997 VDD.t1914 VSS 0.03468f
C6998 VDD.t740 VSS 0.03305f
C6999 VDD.t935 VSS 0.03468f
C7000 VDD.t1819 VSS 0.29173f
C7001 VDD.t516 VSS 0.40091f
C7002 VDD.t8 VSS 0.40091f
C7003 VDD.t2101 VSS 0.40091f
C7004 VDD.t1220 VSS 0.40091f
C7005 VDD.t498 VSS 0.40091f
C7006 VDD.t717 VSS 0.40091f
C7007 VDD.t1548 VSS 0.40091f
C7008 VDD.t882 VSS 0.40091f
C7009 VDD.t2003 VSS 0.40091f
C7010 VDD.t14 VSS 0.40091f
C7011 VDD.t1949 VSS 0.40091f
C7012 VDD.t70 VSS 0.40091f
C7013 VDD.t1913 VSS 0.30963f
C7014 VDD.t739 VSS 0.1915f
C7015 VDD.t934 VSS 0.40091f
C7016 VDD.t725 VSS 0.43965f
C7017 VDD.t726 VSS 0.03305f
C7018 VDD.t1484 VSS 0.03468f
C7019 VDD.t1261 VSS 0.03305f
C7020 VDD.t1190 VSS 0.03468f
C7021 VDD.t134 VSS 0.03305f
C7022 VDD.t1223 VSS 0.03468f
C7023 VDD.t362 VSS 0.03305f
C7024 VDD.t515 VSS 0.03468f
C7025 VDD.t1252 VSS 0.03305f
C7026 VDD.t324 VSS 0.03468f
C7027 VDD.t888 VSS 0.03305f
C7028 VDD.t1998 VSS 0.03468f
C7029 VDD.t722 VSS 0.03305f
C7030 VDD.t2021 VSS 0.03468f
C7031 VDD.n42 VSS 1.07521f
C7032 VDD.t240 VSS 0.03468f
C7033 VDD.t1263 VSS 0.03305f
C7034 VDD.t1822 VSS 0.03468f
C7035 VDD.t287 VSS 0.03305f
C7036 VDD.t1852 VSS 0.03468f
C7037 VDD.t414 VSS 0.03305f
C7038 VDD.t292 VSS 0.03468f
C7039 VDD.t11 VSS 0.03305f
C7040 VDD.t706 VSS 0.03468f
C7041 VDD.t876 VSS 0.03305f
C7042 VDD.t1796 VSS 0.03468f
C7043 VDD.t1270 VSS 0.03305f
C7044 VDD.t1259 VSS 0.03468f
C7045 VDD.t1807 VSS 0.03305f
C7046 VDD.t1265 VSS 0.03468f
C7047 VDD.t1801 VSS 0.03468f
C7048 VDD.t154 VSS 0.03305f
C7049 VDD.t5 VSS 0.03468f
C7050 VDD.t339 VSS 0.03305f
C7051 VDD.t877 VSS 0.03468f
C7052 VDD.t713 VSS 0.03305f
C7053 VDD.t288 VSS 0.03468f
C7054 VDD.t228 VSS 0.03305f
C7055 VDD.t152 VSS 0.03468f
C7056 VDD.t241 VSS 0.03305f
C7057 VDD.t1891 VSS 0.03468f
C7058 VDD.t388 VSS 0.03305f
C7059 VDD.t893 VSS 0.03468f
C7060 VDD.t254 VSS 0.03305f
C7061 VDD.t320 VSS 0.03468f
C7062 VDD.t1268 VSS 0.03305f
C7063 VDD.t1890 VSS 0.03468f
C7064 VDD.t153 VSS 0.59241f
C7065 VDD.t4 VSS 0.80181f
C7066 VDD.t712 VSS 0.80181f
C7067 VDD.t227 VSS 0.80181f
C7068 VDD.t151 VSS 0.80181f
C7069 VDD.t387 VSS 0.80181f
C7070 VDD.t253 VSS 0.80181f
C7071 VDD.t319 VSS 0.61031f
C7072 VDD.n66 VSS 0.1915f
C7073 VDD.t1889 VSS 0.10918f
C7074 VDD.n67 VSS 0.23024f
C7075 VDD.t316 VSS 0.0424f
C7076 VDD.t704 VSS 0.03468f
C7077 VDD.t1895 VSS 0.03468f
C7078 VDD.t273 VSS 0.03468f
C7079 VDD.t45 VSS 0.03468f
C7080 VDD.t1250 VSS 0.03305f
C7081 VDD.t1803 VSS 0.03468f
C7082 VDD.t358 VSS 0.03305f
C7083 VDD.t1267 VSS 0.03468f
C7084 VDD.t734 VSS 0.03305f
C7085 VDD.t1254 VSS 0.03468f
C7086 VDD.t416 VSS 0.03468f
C7087 VDD.t748 VSS 0.03305f
C7088 VDD.t746 VSS 0.03468f
C7089 VDD.t258 VSS 0.03468f
C7090 VDD.t730 VSS 0.0424f
C7091 VDD.t732 VSS 0.03468f
C7092 VDD.t742 VSS 0.03468f
C7093 VDD.t166 VSS 0.03468f
C7094 VDD.t315 VSS 0.1915f
C7095 VDD.t703 VSS 0.29531f
C7096 VDD.t879 VSS 0.33916f
C7097 VDD.t881 VSS 0.21209f
C7098 VDD.t1894 VSS 0.40807f
C7099 VDD.t1810 VSS 0.40091f
C7100 VDD.t272 VSS 0.15034f
C7101 VDD.t1811 VSS 0.29621f
C7102 VDD.t802 VSS 0.30516f
C7103 VDD.t44 VSS 0.10649f
C7104 VDD.t1249 VSS 0.29173f
C7105 VDD.t1802 VSS 0.40091f
C7106 VDD.t357 VSS 0.40091f
C7107 VDD.t1266 VSS 0.2094f
C7108 VDD.t733 VSS 0.29173f
C7109 VDD.t1253 VSS 0.2094f
C7110 VDD.n86 VSS 0.29173f
C7111 VDD.t415 VSS 0.10918f
C7112 VDD.t747 VSS 0.20045f
C7113 VDD.t745 VSS 0.20045f
C7114 VDD.t729 VSS 0.39196f
C7115 VDD.t257 VSS 0.29531f
C7116 VDD.t250 VSS 0.40091f
C7117 VDD.t731 VSS 0.15034f
C7118 VDD.t252 VSS 0.40091f
C7119 VDD.t741 VSS 0.40807f
C7120 VDD.t714 VSS 0.19598f
C7121 VDD.t715 VSS 0.16376f
C7122 VDD.t826 VSS 0.1915f
C7123 VDD.t165 VSS 0.10649f
C7124 VDD.n87 VSS 0.57645f
C7125 VDD.n94 VSS 0.04983f
C7126 VDD.n95 VSS 0.06033f
C7127 VDD.n96 VSS 0.03437f
C7128 VDD.n97 VSS 0.03122f
C7129 VDD.n99 VSS 1.07521f
C7130 VDD.t384 VSS 0.03468f
C7131 VDD.t1761 VSS 0.03305f
C7132 VDD.t1086 VSS 0.03468f
C7133 VDD.t130 VSS 0.03305f
C7134 VDD.t1088 VSS 0.03468f
C7135 VDD.t1783 VSS 0.03305f
C7136 VDD.t1138 VSS 0.03468f
C7137 VDD.t97 VSS 0.03305f
C7138 VDD.t1140 VSS 0.03468f
C7139 VDD.t372 VSS 0.03305f
C7140 VDD.t1994 VSS 0.03468f
C7141 VDD.t39 VSS 0.03305f
C7142 VDD.t1996 VSS 0.03468f
C7143 VDD.t1905 VSS 0.03305f
C7144 VDD.t2002 VSS 0.03468f
C7145 VDD.t146 VSS 0.03305f
C7146 VDD.t2000 VSS 0.03468f
C7147 VDD.t57 VSS 0.03305f
C7148 VDD.t128 VSS 0.03468f
C7149 VDD.t306 VSS 0.03305f
C7150 VDD.t126 VSS 0.03468f
C7151 VDD.t168 VSS 0.03305f
C7152 VDD.t1789 VSS 0.03468f
C7153 VDD.t145 VSS 0.29173f
C7154 VDD.t1999 VSS 0.40091f
C7155 VDD.t56 VSS 0.40091f
C7156 VDD.t127 VSS 0.40091f
C7157 VDD.t305 VSS 0.40091f
C7158 VDD.t125 VSS 0.30963f
C7159 VDD.t167 VSS 0.1915f
C7160 VDD.t1788 VSS 0.2094f
C7161 VDD.n113 VSS 0.56929f
C7162 VDD.n120 VSS 0.04829f
C7163 VDD.n121 VSS 0.06221f
C7164 VDD.n122 VSS 0.06221f
C7165 VDD.n123 VSS 0.06221f
C7166 VDD.t1721 VSS 0.03305f
C7167 VDD.t382 VSS 0.03468f
C7168 VDD.t91 VSS 0.03305f
C7169 VDD.n126 VSS 0.0294f
C7170 VDD.n128 VSS 0.03122f
C7171 VDD.t2001 VSS 0.30068f
C7172 VDD.t1720 VSS 0.2094f
C7173 VDD.t381 VSS 0.1915f
C7174 VDD.t90 VSS 0.30963f
C7175 VDD.t383 VSS 0.40091f
C7176 VDD.t1760 VSS 0.40091f
C7177 VDD.t1085 VSS 0.40091f
C7178 VDD.t129 VSS 0.40091f
C7179 VDD.t1087 VSS 0.40091f
C7180 VDD.t1782 VSS 0.40091f
C7181 VDD.t1137 VSS 0.40091f
C7182 VDD.t96 VSS 0.40091f
C7183 VDD.t1139 VSS 0.40091f
C7184 VDD.t371 VSS 0.40091f
C7185 VDD.t1993 VSS 0.40091f
C7186 VDD.t38 VSS 0.40091f
C7187 VDD.t1995 VSS 0.29173f
C7188 VDD.t1904 VSS 0.43965f
C7189 VDD.t2104 VSS 0.03468f
C7190 VDD.t144 VSS 0.03305f
C7191 VDD.t860 VSS 0.03468f
C7192 VDD.t308 VSS 0.03305f
C7193 VDD.t862 VSS 0.03468f
C7194 VDD.t1897 VSS 0.03305f
C7195 VDD.t2009 VSS 0.03468f
C7196 VDD.t122 VSS 0.03305f
C7197 VDD.t2011 VSS 0.03468f
C7198 VDD.t95 VSS 0.03305f
C7199 VDD.t856 VSS 0.03468f
C7200 VDD.t1775 VSS 0.03305f
C7201 VDD.t858 VSS 0.03468f
C7202 VDD.t142 VSS 0.03305f
C7203 VDD.t63 VSS 0.03468f
C7204 VDD.t326 VSS 0.03305f
C7205 VDD.t65 VSS 0.03468f
C7206 VDD.t304 VSS 0.03305f
C7207 VDD.t2013 VSS 0.03468f
C7208 VDD.t85 VSS 0.03305f
C7209 VDD.t2015 VSS 0.03468f
C7210 VDD.t1961 VSS 0.03305f
C7211 VDD.n145 VSS 0.05102f
C7212 VDD.n146 VSS 1.07521f
C7213 VDD.t2024 VSS 0.03468f
C7214 VDD.t1916 VSS 0.03305f
C7215 VDD.t1933 VSS 0.03468f
C7216 VDD.t1767 VSS 0.03305f
C7217 VDD.t2094 VSS 0.03468f
C7218 VDD.t1517 VSS 0.03305f
C7219 VDD.t1899 VSS 0.03468f
C7220 VDD.t67 VSS 0.03305f
C7221 VDD.t789 VSS 0.03468f
C7222 VDD.t173 VSS 0.03305f
C7223 VDD.t1034 VSS 0.03468f
C7224 VDD.t1963 VSS 0.03305f
C7225 VDD.t1142 VSS 0.03468f
C7226 VDD.t1828 VSS 0.03305f
C7227 VDD.t2060 VSS 0.03468f
C7228 VDD.t1038 VSS 0.03305f
C7229 VDD.t2096 VSS 0.03468f
C7230 VDD.t1954 VSS 0.03305f
C7231 VDD.t338 VSS 0.03468f
C7232 VDD.t1925 VSS 0.03305f
C7233 VDD.t205 VSS 0.03468f
C7234 VDD.t871 VSS 0.03305f
C7235 VDD.t199 VSS 0.03468f
C7236 VDD.t1769 VSS 0.03305f
C7237 VDD.t2098 VSS 0.03468f
C7238 VDD.t183 VSS 0.03305f
C7239 VDD.t2100 VSS 0.03468f
C7240 VDD.t93 VSS 0.03305f
C7241 VDD.t869 VSS 0.03468f
C7242 VDD.t865 VSS 0.03305f
C7243 VDD.t1792 VSS 0.03468f
C7244 VDD.t1037 VSS 0.29173f
C7245 VDD.t2095 VSS 0.40091f
C7246 VDD.t1953 VSS 0.40091f
C7247 VDD.t337 VSS 0.40091f
C7248 VDD.t1924 VSS 0.40091f
C7249 VDD.t204 VSS 0.40091f
C7250 VDD.t870 VSS 0.40091f
C7251 VDD.t198 VSS 0.40091f
C7252 VDD.t1768 VSS 0.40091f
C7253 VDD.t2097 VSS 0.40091f
C7254 VDD.t182 VSS 0.40091f
C7255 VDD.t2099 VSS 0.40091f
C7256 VDD.t92 VSS 0.40091f
C7257 VDD.t868 VSS 0.30963f
C7258 VDD.t864 VSS 0.1915f
C7259 VDD.t1791 VSS 0.40091f
C7260 VDD.t313 VSS 0.43965f
C7261 VDD.t314 VSS 0.03305f
C7262 VDD.t1755 VSS 0.03468f
C7263 VDD.t1779 VSS 0.03305f
C7264 VDD.t1246 VSS 0.03468f
C7265 VDD.t854 VSS 0.03305f
C7266 VDD.t99 VSS 0.03468f
C7267 VDD.t191 VSS 0.03305f
C7268 VDD.t193 VSS 0.03468f
C7269 VDD.t1921 VSS 0.03305f
C7270 VDD.t2058 VSS 0.03468f
C7271 VDD.t101 VSS 0.03305f
C7272 VDD.t1794 VSS 0.03468f
C7273 VDD.t1743 VSS 0.03305f
C7274 VDD.t791 VSS 0.03468f
C7275 VDD.t874 VSS 0.03305f
C7276 VDD.t61 VSS 0.03468f
C7277 VDD.t2018 VSS 0.03305f
C7278 VDD.t1931 VSS 0.03468f
C7279 VDD.t1929 VSS 0.03305f
C7280 VDD.t267 VSS 0.03468f
C7281 VDD.t195 VSS 0.03305f
C7282 VDD.t793 VSS 0.03468f
C7283 VDD.t985 VSS 0.03305f
C7284 VDD.t49 VSS 0.03468f
C7285 VDD.t1909 VSS 0.03305f
C7286 VDD.t348 VSS 0.03468f
C7287 VDD.t1754 VSS 0.29173f
C7288 VDD.t1778 VSS 0.40091f
C7289 VDD.t1245 VSS 0.40091f
C7290 VDD.t853 VSS 0.40091f
C7291 VDD.t98 VSS 0.40091f
C7292 VDD.t190 VSS 0.40091f
C7293 VDD.t192 VSS 0.40091f
C7294 VDD.t1920 VSS 0.40091f
C7295 VDD.t2057 VSS 0.40091f
C7296 VDD.t100 VSS 0.40091f
C7297 VDD.t1793 VSS 0.40091f
C7298 VDD.t1742 VSS 0.40091f
C7299 VDD.t790 VSS 0.40091f
C7300 VDD.t873 VSS 0.30963f
C7301 VDD.t60 VSS 0.1915f
C7302 VDD.t2017 VSS 0.2094f
C7303 VDD.t1930 VSS 0.30068f
C7304 VDD.t1928 VSS 0.29173f
C7305 VDD.t266 VSS 0.40091f
C7306 VDD.t194 VSS 0.40091f
C7307 VDD.t792 VSS 0.40091f
C7308 VDD.t984 VSS 0.40091f
C7309 VDD.t48 VSS 0.30963f
C7310 VDD.t1908 VSS 0.1915f
C7311 VDD.t347 VSS 0.2094f
C7312 VDD.n183 VSS 0.56929f
C7313 VDD.n190 VSS 0.04829f
C7314 VDD.n191 VSS 0.06221f
C7315 VDD.n192 VSS 0.06221f
C7316 VDD.n193 VSS 0.06221f
C7317 VDD.n194 VSS 0.03122f
C7318 VDD.n196 VSS 0.0294f
C7319 VDD.n197 VSS 0.08045f
C7320 VDD.n198 VSS 0.04282f
C7321 VDD.n199 VSS 0.06221f
C7322 VDD.n200 VSS 0.06221f
C7323 VDD.n201 VSS 0.06221f
C7324 VDD.n202 VSS 0.06221f
C7325 VDD.n203 VSS 0.06221f
C7326 VDD.n204 VSS 0.05326f
C7327 VDD.n205 VSS 0.05326f
C7328 VDD.n206 VSS 0.06221f
C7329 VDD.n207 VSS 0.06221f
C7330 VDD.n208 VSS 0.06221f
C7331 VDD.n209 VSS 0.06221f
C7332 VDD.n210 VSS 0.06221f
C7333 VDD.n211 VSS 0.06221f
C7334 VDD.n212 VSS 0.06221f
C7335 VDD.t754 VSS 0.03305f
C7336 VDD.t35 VSS 0.03468f
C7337 VDD.t1235 VSS 0.03305f
C7338 VDD.n215 VSS 0.0294f
C7339 VDD.n216 VSS 0.0294f
C7340 VDD.n217 VSS 0.03122f
C7341 VDD.t2059 VSS 0.40986f
C7342 VDD.t753 VSS 0.40091f
C7343 VDD.t34 VSS 0.1915f
C7344 VDD.t1234 VSS 0.30963f
C7345 VDD.t2023 VSS 0.40091f
C7346 VDD.t1915 VSS 0.40091f
C7347 VDD.t1932 VSS 0.40091f
C7348 VDD.t1766 VSS 0.40091f
C7349 VDD.t2093 VSS 0.40091f
C7350 VDD.t1516 VSS 0.40091f
C7351 VDD.t1898 VSS 0.40091f
C7352 VDD.t66 VSS 0.40091f
C7353 VDD.t788 VSS 0.40091f
C7354 VDD.t172 VSS 0.40091f
C7355 VDD.t1033 VSS 0.40091f
C7356 VDD.t1962 VSS 0.40091f
C7357 VDD.t1141 VSS 0.29173f
C7358 VDD.t1827 VSS 0.43965f
C7359 VDD.t1225 VSS 0.03468f
C7360 VDD.t376 VSS 0.03305f
C7361 VDD.t1227 VSS 0.03468f
C7362 VDD.t124 VSS 0.03305f
C7363 VDD.t1394 VSS 0.03468f
C7364 VDD.t55 VSS 0.03305f
C7365 VDD.t1396 VSS 0.03468f
C7366 VDD.t207 VSS 0.03305f
C7367 VDD.t604 VSS 0.03468f
C7368 VDD.t197 VSS 0.03305f
C7369 VDD.t606 VSS 0.03468f
C7370 VDD.t1765 VSS 0.03305f
C7371 VDD.t642 VSS 0.03468f
C7372 VDD.t386 VSS 0.03305f
C7373 VDD.t644 VSS 0.03468f
C7374 VDD.t983 VSS 0.03305f
C7375 VDD.t633 VSS 0.03468f
C7376 VDD.t634 VSS 0.03468f
C7377 VDD.t310 VSS 0.03305f
C7378 VDD.t1732 VSS 0.03468f
C7379 VDD.t312 VSS 0.03305f
C7380 VDD.t1733 VSS 0.03468f
C7381 VDD.t269 VSS 0.03305f
C7382 VDD.t1735 VSS 0.03468f
C7383 VDD.t1790 VSS 0.03305f
C7384 VDD.t1737 VSS 0.03468f
C7385 VDD.t1957 VSS 0.03305f
C7386 VDD.t1739 VSS 0.03468f
C7387 VDD.t2016 VSS 0.03305f
C7388 VDD.t1741 VSS 0.03468f
C7389 VDD.t1919 VSS 0.03305f
C7390 VDD.t1785 VSS 0.03468f
C7391 VDD.t937 VSS 0.03305f
C7392 VDD.t1224 VSS 0.40091f
C7393 VDD.t375 VSS 0.1915f
C7394 VDD.t1226 VSS 0.30963f
C7395 VDD.t123 VSS 0.40091f
C7396 VDD.t1393 VSS 0.40091f
C7397 VDD.t54 VSS 0.40091f
C7398 VDD.t1395 VSS 0.40091f
C7399 VDD.t206 VSS 0.40091f
C7400 VDD.t603 VSS 0.40091f
C7401 VDD.t196 VSS 0.40091f
C7402 VDD.t605 VSS 0.40091f
C7403 VDD.t1764 VSS 0.40091f
C7404 VDD.t641 VSS 0.40091f
C7405 VDD.t385 VSS 0.40091f
C7406 VDD.t643 VSS 0.40091f
C7407 VDD.t982 VSS 0.29173f
C7408 VDD.t632 VSS 0.30068f
C7409 VDD.t309 VSS 0.61031f
C7410 VDD.t311 VSS 0.80181f
C7411 VDD.t268 VSS 0.80181f
C7412 VDD.t1734 VSS 0.80181f
C7413 VDD.t1736 VSS 0.80181f
C7414 VDD.t1738 VSS 0.80181f
C7415 VDD.t1740 VSS 0.80181f
C7416 VDD.t936 VSS 0.59241f
C7417 VDD.n244 VSS 0.48696f
C7418 VDD.n251 VSS 1.07521f
C7419 VDD.t1658 VSS 0.03468f
C7420 VDD.t1525 VSS 0.03305f
C7421 VDD.t1659 VSS 0.03468f
C7422 VDD.t1527 VSS 0.03305f
C7423 VDD.t1323 VSS 0.03468f
C7424 VDD.t1528 VSS 0.03305f
C7425 VDD.t1324 VSS 0.03468f
C7426 VDD.t1163 VSS 0.03305f
C7427 VDD.t1325 VSS 0.03468f
C7428 VDD.t1165 VSS 0.03305f
C7429 VDD.t811 VSS 0.03468f
C7430 VDD.t1166 VSS 0.03305f
C7431 VDD.t813 VSS 0.03468f
C7432 VDD.t1472 VSS 0.03305f
C7433 VDD.t1560 VSS 0.03468f
C7434 VDD.t777 VSS 0.03305f
C7435 VDD.t1558 VSS 0.03468f
C7436 VDD.t775 VSS 0.03305f
C7437 VDD.t1556 VSS 0.03468f
C7438 VDD.t901 VSS 0.03305f
C7439 VDD.t691 VSS 0.03468f
C7440 VDD.t899 VSS 0.03305f
C7441 VDD.t689 VSS 0.03468f
C7442 VDD.t897 VSS 0.03305f
C7443 VDD.t687 VSS 0.03468f
C7444 VDD.t1844 VSS 0.03305f
C7445 VDD.t915 VSS 0.03468f
C7446 VDD.t1842 VSS 0.03305f
C7447 VDD.t913 VSS 0.03468f
C7448 VDD.t1840 VSS 0.03305f
C7449 VDD.t911 VSS 0.03468f
C7450 VDD.t776 VSS 0.29173f
C7451 VDD.t1557 VSS 0.40091f
C7452 VDD.t774 VSS 0.40091f
C7453 VDD.t1555 VSS 0.40091f
C7454 VDD.t900 VSS 0.40091f
C7455 VDD.t690 VSS 0.40091f
C7456 VDD.t898 VSS 0.40091f
C7457 VDD.t688 VSS 0.40091f
C7458 VDD.t896 VSS 0.40091f
C7459 VDD.t686 VSS 0.40091f
C7460 VDD.t1843 VSS 0.40091f
C7461 VDD.t914 VSS 0.40091f
C7462 VDD.t1841 VSS 0.40091f
C7463 VDD.t912 VSS 0.30963f
C7464 VDD.t1839 VSS 0.1915f
C7465 VDD.t910 VSS 0.40091f
C7466 VDD.t1353 VSS 0.43965f
C7467 VDD.t1354 VSS 0.03305f
C7468 VDD.t1432 VSS 0.03468f
C7469 VDD.t1352 VSS 0.03305f
C7470 VDD.t1430 VSS 0.03468f
C7471 VDD.t1350 VSS 0.03305f
C7472 VDD.t1428 VSS 0.03468f
C7473 VDD.t658 VSS 0.03305f
C7474 VDD.t586 VSS 0.03468f
C7475 VDD.t656 VSS 0.03305f
C7476 VDD.t584 VSS 0.03468f
C7477 VDD.t654 VSS 0.03305f
C7478 VDD.t582 VSS 0.03468f
C7479 VDD.t592 VSS 0.03305f
C7480 VDD.t1019 VSS 0.03457f
C7481 VDD.t590 VSS 0.03305f
C7482 VDD.t981 VSS 0.03468f
C7483 VDD.t588 VSS 0.03305f
C7484 VDD.t980 VSS 0.03468f
C7485 VDD.t1305 VSS 0.03305f
C7486 VDD.t978 VSS 0.03468f
C7487 VDD.t1303 VSS 0.03305f
C7488 VDD.t1178 VSS 0.03468f
C7489 VDD.t1301 VSS 0.03305f
C7490 VDD.t1176 VSS 0.03468f
C7491 VDD.t1612 VSS 0.03305f
C7492 VDD.t1174 VSS 0.03468f
C7493 VDD.t1610 VSS 0.03305f
C7494 VDD.t1547 VSS 0.03468f
C7495 VDD.t1608 VSS 0.03305f
C7496 VDD.t1545 VSS 0.03468f
C7497 VDD.t1618 VSS 0.03305f
C7498 VDD.t1543 VSS 0.03468f
C7499 VDD.t1616 VSS 0.03305f
C7500 VDD.t1431 VSS 0.29173f
C7501 VDD.t1351 VSS 0.40091f
C7502 VDD.t1429 VSS 0.40091f
C7503 VDD.t1349 VSS 0.40091f
C7504 VDD.t1427 VSS 0.40091f
C7505 VDD.t657 VSS 0.40091f
C7506 VDD.t585 VSS 0.40091f
C7507 VDD.t655 VSS 0.2094f
C7508 VDD.t583 VSS 0.29173f
C7509 VDD.t653 VSS 0.40091f
C7510 VDD.t581 VSS 0.40091f
C7511 VDD.t591 VSS 0.2094f
C7512 VDD.t1018 VSS 0.1915f
C7513 VDD.t589 VSS 0.23625f
C7514 VDD.t587 VSS 0.49218f
C7515 VDD.n292 VSS 0.40091f
C7516 VDD.t979 VSS 0.10918f
C7517 VDD.t1304 VSS 0.39196f
C7518 VDD.t977 VSS 0.40091f
C7519 VDD.t1302 VSS 0.40091f
C7520 VDD.t1177 VSS 0.40091f
C7521 VDD.t1300 VSS 0.40091f
C7522 VDD.t1175 VSS 0.40091f
C7523 VDD.t1611 VSS 0.40091f
C7524 VDD.t1173 VSS 0.40091f
C7525 VDD.t1609 VSS 0.40091f
C7526 VDD.t1546 VSS 0.40091f
C7527 VDD.t1607 VSS 0.40091f
C7528 VDD.t1544 VSS 0.40091f
C7529 VDD.t1617 VSS 0.2094f
C7530 VDD.t1542 VSS 0.39196f
C7531 VDD.t1615 VSS 0.2094f
C7532 VDD.t1613 VSS 0.33048f
C7533 VDD.t1614 VSS 0.03305f
C7534 VDD.t905 VSS 0.03468f
C7535 VDD.t1172 VSS 0.03305f
C7536 VDD.t903 VSS 0.03468f
C7537 VDD.t1170 VSS 0.03305f
C7538 VDD.t281 VSS 0.03468f
C7539 VDD.t1168 VSS 0.03305f
C7540 VDD.t279 VSS 0.03468f
C7541 VDD.t1688 VSS 0.03305f
C7542 VDD.t277 VSS 0.03468f
C7543 VDD.t1686 VSS 0.03305f
C7544 VDD.t544 VSS 0.03468f
C7545 VDD.t1684 VSS 0.03305f
C7546 VDD.t542 VSS 0.03468f
C7547 VDD.t538 VSS 0.03305f
C7548 VDD.t540 VSS 0.03468f
C7549 VDD.t536 VSS 0.03305f
C7550 VDD.t839 VSS 0.03468f
C7551 VDD.t534 VSS 0.03305f
C7552 VDD.t837 VSS 0.03468f
C7553 VDD.t452 VSS 0.03305f
C7554 VDD.t835 VSS 0.03468f
C7555 VDD.t450 VSS 0.03305f
C7556 VDD.t1476 VSS 0.03468f
C7557 VDD.t448 VSS 0.03305f
C7558 VDD.t1474 VSS 0.03468f
C7559 VDD.t904 VSS 0.29173f
C7560 VDD.t1171 VSS 0.40091f
C7561 VDD.t902 VSS 0.40091f
C7562 VDD.t1169 VSS 0.40091f
C7563 VDD.t280 VSS 0.40091f
C7564 VDD.t1167 VSS 0.40091f
C7565 VDD.t278 VSS 0.40091f
C7566 VDD.t1687 VSS 0.40091f
C7567 VDD.t276 VSS 0.40091f
C7568 VDD.t1685 VSS 0.40091f
C7569 VDD.t543 VSS 0.40091f
C7570 VDD.t1683 VSS 0.40091f
C7571 VDD.t541 VSS 0.40091f
C7572 VDD.t537 VSS 0.30963f
C7573 VDD.t539 VSS 0.1915f
C7574 VDD.t535 VSS 0.2094f
C7575 VDD.t838 VSS 0.30068f
C7576 VDD.t533 VSS 0.29173f
C7577 VDD.t836 VSS 0.40091f
C7578 VDD.t451 VSS 0.40091f
C7579 VDD.t834 VSS 0.40091f
C7580 VDD.t449 VSS 0.40091f
C7581 VDD.t1475 VSS 0.30963f
C7582 VDD.t447 VSS 0.1915f
C7583 VDD.t1473 VSS 0.2094f
C7584 VDD.n312 VSS 0.56929f
C7585 VDD.n319 VSS 0.04829f
C7586 VDD.n320 VSS 0.06221f
C7587 VDD.n321 VSS 0.06221f
C7588 VDD.n322 VSS 0.06221f
C7589 VDD.n323 VSS 0.03122f
C7590 VDD.n325 VSS 0.0294f
C7591 VDD.n326 VSS 1.07521f
C7592 VDD.t548 VSS 0.03468f
C7593 VDD.t2030 VSS 0.03305f
C7594 VDD.t550 VSS 0.03468f
C7595 VDD.t2032 VSS 0.03305f
C7596 VDD.t1311 VSS 0.03468f
C7597 VDD.t2034 VSS 0.03305f
C7598 VDD.t1313 VSS 0.03468f
C7599 VDD.t400 VSS 0.03305f
C7600 VDD.t1315 VSS 0.03468f
C7601 VDD.t402 VSS 0.03305f
C7602 VDD.t917 VSS 0.03468f
C7603 VDD.t404 VSS 0.03305f
C7604 VDD.t919 VSS 0.03468f
C7605 VDD.t1307 VSS 0.03305f
C7606 VDD.t1859 VSS 0.03468f
C7607 VDD.t636 VSS 0.03305f
C7608 VDD.t1857 VSS 0.03468f
C7609 VDD.t1682 VSS 0.03305f
C7610 VDD.t1855 VSS 0.03468f
C7611 VDD.t1680 VSS 0.03305f
C7612 VDD.t1622 VSS 0.03468f
C7613 VDD.t1678 VSS 0.03305f
C7614 VDD.t1620 VSS 0.03468f
C7615 VDD.t635 VSS 0.29173f
C7616 VDD.t1856 VSS 0.40091f
C7617 VDD.t1681 VSS 0.40091f
C7618 VDD.t1854 VSS 0.40091f
C7619 VDD.t1679 VSS 0.40091f
C7620 VDD.t1621 VSS 0.30963f
C7621 VDD.t1677 VSS 0.1915f
C7622 VDD.t1619 VSS 0.2094f
C7623 VDD.n340 VSS 0.56929f
C7624 VDD.n347 VSS 0.04829f
C7625 VDD.n348 VSS 0.06221f
C7626 VDD.n349 VSS 0.06221f
C7627 VDD.n350 VSS 0.06221f
C7628 VDD.t638 VSS 0.03305f
C7629 VDD.t546 VSS 0.03468f
C7630 VDD.t640 VSS 0.03305f
C7631 VDD.n353 VSS 0.0294f
C7632 VDD.n355 VSS 0.03122f
C7633 VDD.t1858 VSS 0.30068f
C7634 VDD.t637 VSS 0.2094f
C7635 VDD.t545 VSS 0.1915f
C7636 VDD.t639 VSS 0.30963f
C7637 VDD.t547 VSS 0.40091f
C7638 VDD.t2029 VSS 0.40091f
C7639 VDD.t549 VSS 0.40091f
C7640 VDD.t2031 VSS 0.40091f
C7641 VDD.t1310 VSS 0.40091f
C7642 VDD.t2033 VSS 0.40091f
C7643 VDD.t1312 VSS 0.40091f
C7644 VDD.t399 VSS 0.40091f
C7645 VDD.t1314 VSS 0.40091f
C7646 VDD.t401 VSS 0.40091f
C7647 VDD.t916 VSS 0.40091f
C7648 VDD.t403 VSS 0.40091f
C7649 VDD.t918 VSS 0.29173f
C7650 VDD.t1306 VSS 0.33048f
C7651 VDD.t1288 VSS 0.03468f
C7652 VDD.t1308 VSS 0.03305f
C7653 VDD.t1290 VSS 0.03468f
C7654 VDD.t1309 VSS 0.03305f
C7655 VDD.t1291 VSS 0.03468f
C7656 VDD.t1003 VSS 0.03305f
C7657 VDD.t1005 VSS 0.03305f
C7658 VDD.t1040 VSS 0.03457f
C7659 VDD.t1007 VSS 0.03305f
C7660 VDD.t440 VSS 0.04699f
C7661 VDD.n365 VSS 0.0262f
C7662 VDD.t1446 VSS 0.03305f
C7663 VDD.t444 VSS 0.03305f
C7664 VDD.t1448 VSS 0.03305f
C7665 VDD.t1450 VSS 0.03305f
C7666 VDD.t943 VSS 0.0278f
C7667 VDD.n374 VSS 0.04094f
C7668 VDD.n376 VSS 0.03134f
C7669 VDD.t945 VSS 0.03305f
C7670 VDD.n380 VSS 0.03527f
C7671 VDD.t947 VSS 0.03305f
C7672 VDD.t1590 VSS 0.03468f
C7673 VDD.t1416 VSS 0.03305f
C7674 VDD.t1418 VSS 0.03305f
C7675 VDD.t1596 VSS 0.0278f
C7676 VDD.n384 VSS 0.04127f
C7677 VDD.n385 VSS 0.03167f
C7678 VDD.n386 VSS 0.03507f
C7679 VDD.t1287 VSS 0.40091f
C7680 VDD.t1289 VSS 0.61031f
C7681 VDD.t1002 VSS 0.59241f
C7682 VDD.t1004 VSS 0.23625f
C7683 VDD.t1039 VSS 0.1915f
C7684 VDD.t1006 VSS 0.25057f
C7685 VDD.t439 VSS 0.22372f
C7686 VDD.t443 VSS 0.35974f
C7687 VDD.t1445 VSS 0.31142f
C7688 VDD.t437 VSS 0.35616f
C7689 VDD.t441 VSS 0.26667f
C7690 VDD.t1447 VSS 0.1396f
C7691 VDD.t809 VSS 0.3499f
C7692 VDD.t1017 VSS 0.30605f
C7693 VDD.t1449 VSS 0.24251f
C7694 VDD.t445 VSS 0.10918f
C7695 VDD.n393 VSS 0.1933f
C7696 VDD.t804 VSS 0.1915f
C7697 VDD.t1016 VSS 0.10739f
C7698 VDD.t1041 VSS 0.17184f
C7699 VDD.t806 VSS 0.14233f
C7700 VDD.n394 VSS 0.18918f
C7701 VDD.t942 VSS 0.12797f
C7702 VDD.t807 VSS 0.20045f
C7703 VDD.t940 VSS 0.33111f
C7704 VDD.t938 VSS 0.25594f
C7705 VDD.t1014 VSS 0.23804f
C7706 VDD.t1649 VSS 0.24699f
C7707 VDD.t944 VSS 0.22193f
C7708 VDD.t1020 VSS 0.32753f
C7709 VDD.t1758 VSS 0.28815f
C7710 VDD.t946 VSS 0.16466f
C7711 VDD.t1589 VSS 0.30963f
C7712 VDD.t1415 VSS 0.1915f
C7713 VDD.t1283 VSS 0.20224f
C7714 VDD.t1417 VSS 0.23446f
C7715 VDD.t1595 VSS 0.1915f
C7716 VDD.t1593 VSS 0.10739f
C7717 VDD.t645 VSS 0.1915f
C7718 VDD.t1591 VSS 0.21477f
C7719 VDD.t1419 VSS 0.31142f
C7720 VDD.n395 VSS 0.43427f
C7721 VDD.t991 VSS 0.03305f
C7722 VDD.n397 VSS 0.03527f
C7723 VDD.t993 VSS 0.03305f
C7724 VDD.t511 VSS 0.03468f
C7725 VDD.t995 VSS 0.03305f
C7726 VDD.t513 VSS 0.03468f
C7727 VDD.t1661 VSS 0.03305f
C7728 VDD.t392 VSS 0.03468f
C7729 VDD.t1663 VSS 0.03305f
C7730 VDD.t394 VSS 0.03468f
C7731 VDD.t1665 VSS 0.03305f
C7732 VDD.t396 VSS 0.03468f
C7733 VDD.t1404 VSS 0.03305f
C7734 VDD.t2062 VSS 0.03468f
C7735 VDD.t1406 VSS 0.03305f
C7736 VDD.t2064 VSS 0.03468f
C7737 VDD.t2065 VSS 0.03468f
C7738 VDD.t1408 VSS 0.03305f
C7739 VDD.t1045 VSS 0.03468f
C7740 VDD.t626 VSS 0.03305f
C7741 VDD.t1046 VSS 0.03468f
C7742 VDD.t628 VSS 0.03305f
C7743 VDD.t1047 VSS 0.03468f
C7744 VDD.t630 VSS 0.03305f
C7745 VDD.t1674 VSS 0.03468f
C7746 VDD.t558 VSS 0.03305f
C7747 VDD.t1675 VSS 0.03468f
C7748 VDD.t560 VSS 0.03305f
C7749 VDD.t1676 VSS 0.03468f
C7750 VDD.t562 VSS 0.03305f
C7751 VDD.t1457 VSS 0.03468f
C7752 VDD.t960 VSS 0.03305f
C7753 VDD.t1964 VSS 0.20224f
C7754 VDD.t990 VSS 0.21477f
C7755 VDD.t508 VSS 0.40091f
C7756 VDD.t992 VSS 0.40449f
C7757 VDD.t510 VSS 0.30963f
C7758 VDD.t994 VSS 0.1915f
C7759 VDD.t512 VSS 0.30963f
C7760 VDD.t1660 VSS 0.40091f
C7761 VDD.t391 VSS 0.40091f
C7762 VDD.t1662 VSS 0.1915f
C7763 VDD.t393 VSS 0.30963f
C7764 VDD.t1664 VSS 0.40091f
C7765 VDD.t395 VSS 0.40091f
C7766 VDD.t1403 VSS 0.40091f
C7767 VDD.t2061 VSS 0.40091f
C7768 VDD.t1405 VSS 0.29173f
C7769 VDD.t2063 VSS 0.30068f
C7770 VDD.t1407 VSS 0.61031f
C7771 VDD.t625 VSS 0.80181f
C7772 VDD.t627 VSS 0.80181f
C7773 VDD.t629 VSS 0.80181f
C7774 VDD.t557 VSS 0.80181f
C7775 VDD.t559 VSS 0.80181f
C7776 VDD.t561 VSS 0.80181f
C7777 VDD.t959 VSS 0.59241f
C7778 VDD.n419 VSS 0.48696f
C7779 VDD.n426 VSS 0.09437f
C7780 VDD.n427 VSS 0.03122f
C7781 VDD.n428 VSS 0.06221f
C7782 VDD.n429 VSS 0.06221f
C7783 VDD.n430 VSS 0.06221f
C7784 VDD.n431 VSS 0.05326f
C7785 VDD.n432 VSS 0.06221f
C7786 VDD.n433 VSS 0.05326f
C7787 VDD.n434 VSS 0.05326f
C7788 VDD.n435 VSS 0.0294f
C7789 VDD.n436 VSS 0.04914f
C7790 VDD.n437 VSS 0.04083f
C7791 VDD.n438 VSS 0.05326f
C7792 VDD.n439 VSS 0.04332f
C7793 VDD.n441 VSS 0.05583f
C7794 VDD.n442 VSS 1.07521f
C7795 VDD.n445 VSS 0.03134f
C7796 VDD.t1508 VSS 0.03305f
C7797 VDD.t1506 VSS 0.04699f
C7798 VDD.n448 VSS 0.0262f
C7799 VDD.t2090 VSS 0.04699f
C7800 VDD.n449 VSS 0.0262f
C7801 VDD.t2088 VSS 0.03305f
C7802 VDD.n451 VSS 0.03527f
C7803 VDD.t1504 VSS 0.03468f
C7804 VDD.t1886 VSS 0.0278f
C7805 VDD.n454 VSS 0.04127f
C7806 VDD.n457 VSS 0.03167f
C7807 VDD.t1271 VSS 0.14207f
C7808 VDD.t211 VSS 0.32753f
C7809 VDD.t1878 VSS 0.03305f
C7810 VDD.t1295 VSS 0.04699f
C7811 VDD.n462 VSS 0.0262f
C7812 VDD.t1297 VSS 0.03305f
C7813 VDD.t1642 VSS 0.0278f
C7814 VDD.n467 VSS 0.04127f
C7815 VDD.n470 VSS 0.03167f
C7816 VDD.t685 VSS 0.03468f
C7817 VDD.t1877 VSS 0.18614f
C7818 VDD.t209 VSS 0.10739f
C7819 VDD.t669 VSS 0.09844f
C7820 VDD.t208 VSS 0.14233f
C7821 VDD.n474 VSS 0.19813f
C7822 VDD.t1294 VSS 0.29981f
C7823 VDD.t666 VSS 0.18256f
C7824 VDD.t1296 VSS 0.37585f
C7825 VDD.t1975 VSS 0.32216f
C7826 VDD.t670 VSS 0.1933f
C7827 VDD.t1587 VSS 0.21119f
C7828 VDD.t1298 VSS 0.07517f
C7829 VDD.t1968 VSS 0.10739f
C7830 VDD.t1971 VSS 0.14676f
C7831 VDD.t435 VSS 0.26757f
C7832 VDD.t1135 VSS 0.23446f
C7833 VDD.t1641 VSS 0.1933f
C7834 VDD.t1133 VSS 0.20045f
C7835 VDD.t1643 VSS 0.13244f
C7836 VDD.t1972 VSS 0.11812f
C7837 VDD.t1645 VSS 0.1721f
C7838 VDD.t846 VSS 0.14207f
C7839 VDD.n475 VSS 0.26614f
C7840 VDD.t1969 VSS 0.1915f
C7841 VDD.t684 VSS 0.35079f
C7842 VDD.t1973 VSS 0.1915f
C7843 VDD.n476 VSS 0.21235f
C7844 VDD.t1465 VSS 0.03468f
C7845 VDD.t1132 VSS 0.03305f
C7846 VDD.t801 VSS 0.03468f
C7847 VDD.t1027 VSS 0.03305f
C7848 VDD.t799 VSS 0.03468f
C7849 VDD.t1025 VSS 0.03305f
C7850 VDD.t797 VSS 0.03468f
C7851 VDD.t1023 VSS 0.03305f
C7852 VDD.t1066 VSS 0.03305f
C7853 VDD.t1064 VSS 0.03305f
C7854 VDD.t1062 VSS 0.03305f
C7855 VDD.t1001 VSS 0.03305f
C7856 VDD.t999 VSS 0.03305f
C7857 VDD.t997 VSS 0.03305f
C7858 VDD.t952 VSS 0.03305f
C7859 VDD.t850 VSS 0.03305f
C7860 VDD.t956 VSS 0.04699f
C7861 VDD.n494 VSS 0.0262f
C7862 VDD.t848 VSS 0.03305f
C7863 VDD.t1571 VSS 0.10202f
C7864 VDD.t1464 VSS 0.1915f
C7865 VDD.t1131 VSS 0.40091f
C7866 VDD.t800 VSS 0.40091f
C7867 VDD.t1026 VSS 0.40091f
C7868 VDD.t798 VSS 0.40091f
C7869 VDD.t1024 VSS 0.40091f
C7870 VDD.t796 VSS 0.40091f
C7871 VDD.t1022 VSS 0.2094f
C7872 VDD.t1065 VSS 0.16466f
C7873 VDD.t494 VSS 0.25594f
C7874 VDD.t529 VSS 0.32753f
C7875 VDD.t1063 VSS 0.38659f
C7876 VDD.t526 VSS 0.36959f
C7877 VDD.t948 VSS 0.18886f
C7878 VDD.t1061 VSS 0.12531f
C7879 VDD.n498 VSS 0.31625f
C7880 VDD.t531 VSS 0.19866f
C7881 VDD.t524 VSS 0.14139f
C7882 VDD.t1000 VSS 0.1933f
C7883 VDD.t957 VSS 0.30068f
C7884 VDD.n503 VSS 0.22551f
C7885 VDD.t532 VSS 0.1915f
C7886 VDD.t998 VSS 0.25504f
C7887 VDD.t528 VSS 0.2452f
C7888 VDD.t953 VSS 0.29531f
C7889 VDD.t996 VSS 0.22193f
C7890 VDD.t949 VSS 0.37764f
C7891 VDD.t951 VSS 0.33469f
C7892 VDD.t849 VSS 0.18256f
C7893 VDD.t955 VSS 0.40091f
C7894 VDD.t847 VSS 0.25057f
C7895 VDD.n504 VSS 0.56929f
C7896 VDD.n511 VSS 0.03437f
C7897 VDD.n512 VSS 0.0637f
C7898 VDD.n513 VSS 0.04978f
C7899 VDD.n514 VSS 0.08657f
C7900 VDD.n515 VSS 0.03122f
C7901 VDD.n517 VSS 0.08955f
C7902 VDD.n518 VSS 0.09437f
C7903 VDD.n519 VSS 0.03238f
C7904 VDD.n520 VSS 0.04332f
C7905 VDD.n521 VSS 0.03437f
C7906 VDD.n522 VSS 0.06221f
C7907 VDD.n523 VSS 0.06221f
C7908 VDD.n524 VSS 0.06221f
C7909 VDD.n526 VSS 0.04926f
C7910 VDD.n527 VSS 0.06653f
C7911 VDD.n528 VSS 0.04889f
C7912 VDD.n529 VSS 0.05088f
C7913 VDD.n530 VSS 0.07226f
C7914 VDD.n531 VSS 0.03299f
C7915 VDD.t2084 VSS 0.0278f
C7916 VDD.n532 VSS 0.04094f
C7917 VDD.n534 VSS 0.07373f
C7918 VDD.n535 VSS 0.03122f
C7919 VDD.n540 VSS 0.26757f
C7920 VDD.t668 VSS 0.19866f
C7921 VDD.t908 VSS 0.10739f
C7922 VDD.t665 VSS 0.18971f
C7923 VDD.t1509 VSS 0.18435f
C7924 VDD.t2083 VSS 0.22193f
C7925 VDD.t1647 VSS 0.20045f
C7926 VDD.t2081 VSS 0.22372f
C7927 VDD.t2079 VSS 0.28815f
C7928 VDD.t1507 VSS 0.27025f
C7929 VDD.t1505 VSS 0.21477f
C7930 VDD.t2089 VSS 0.42239f
C7931 VDD.t1501 VSS 0.18256f
C7932 VDD.t2087 VSS 0.21477f
C7933 VDD.t1718 VSS 0.31142f
C7934 VDD.t2091 VSS 0.16466f
C7935 VDD.t2085 VSS 0.2094f
C7936 VDD.t1503 VSS 0.1396f
C7937 VDD.t1535 VSS 0.1915f
C7938 VDD.t1669 VSS 0.05727f
C7939 VDD.t1879 VSS 0.24072f
C7940 VDD.t1885 VSS 0.26131f
C7941 VDD.t1529 VSS 0.20045f
C7942 VDD.t1883 VSS 0.1933f
C7943 VDD.t1531 VSS 0.15213f
C7944 VDD.t1668 VSS 0.18077f
C7945 VDD.t1881 VSS 0.23832f
C7946 VDD.n541 VSS 0.20886f
C7947 VDD.n542 VSS 0.15776f
C7948 VDD.t1554 VSS 0.03457f
C7949 VDD.t1273 VSS 0.03468f
C7950 VDD.t1275 VSS 0.03468f
C7951 VDD.t1671 VSS 0.03305f
C7952 VDD.t1398 VSS 0.03468f
C7953 VDD.t1673 VSS 0.03305f
C7954 VDD.t1400 VSS 0.03468f
C7955 VDD.t1834 VSS 0.03305f
C7956 VDD.t1402 VSS 0.03468f
C7957 VDD.t1836 VSS 0.03305f
C7958 VDD.t1229 VSS 0.03468f
C7959 VDD.t1838 VSS 0.03305f
C7960 VDD.t1231 VSS 0.03468f
C7961 VDD.t660 VSS 0.03305f
C7962 VDD.t1233 VSS 0.03468f
C7963 VDD.t1934 VSS 0.03468f
C7964 VDD.t662 VSS 0.03305f
C7965 VDD.t1935 VSS 0.03468f
C7966 VDD.t664 VSS 0.03305f
C7967 VDD.t1937 VSS 0.03468f
C7968 VDD.t2070 VSS 0.03305f
C7969 VDD.t1512 VSS 0.03468f
C7970 VDD.t2071 VSS 0.03305f
C7971 VDD.t1514 VSS 0.03468f
C7972 VDD.t2072 VSS 0.03305f
C7973 VDD.t1515 VSS 0.03468f
C7974 VDD.t1208 VSS 0.03305f
C7975 VDD.t1551 VSS 0.03468f
C7976 VDD.t1210 VSS 0.03305f
C7977 VDD.t1552 VSS 0.03468f
C7978 VDD.t1212 VSS 0.03305f
C7979 VDD.t1533 VSS 0.32753f
C7980 VDD.t1553 VSS 0.38659f
C7981 VDD.t1666 VSS 0.16466f
C7982 VDD.t1285 VSS 0.2094f
C7983 VDD.t1272 VSS 0.16466f
C7984 VDD.t1274 VSS 0.2094f
C7985 VDD.t1670 VSS 0.40091f
C7986 VDD.t1397 VSS 0.40091f
C7987 VDD.t1672 VSS 0.29173f
C7988 VDD.t1399 VSS 0.2094f
C7989 VDD.t1833 VSS 0.40091f
C7990 VDD.t1401 VSS 0.40091f
C7991 VDD.t1835 VSS 0.40091f
C7992 VDD.t1228 VSS 0.40091f
C7993 VDD.t1837 VSS 0.40091f
C7994 VDD.t1230 VSS 0.40091f
C7995 VDD.t659 VSS 0.29173f
C7996 VDD.t1232 VSS 0.30068f
C7997 VDD.t661 VSS 0.61031f
C7998 VDD.t663 VSS 0.80181f
C7999 VDD.t1936 VSS 0.80181f
C8000 VDD.t1511 VSS 0.80181f
C8001 VDD.t1513 VSS 0.80181f
C8002 VDD.t1207 VSS 0.80181f
C8003 VDD.t1209 VSS 0.80181f
C8004 VDD.t1211 VSS 0.59241f
C8005 VDD.n566 VSS 0.48696f
C8006 VDD.n573 VSS 1.07521f
C8007 VDD.t1478 VSS 0.03468f
C8008 VDD.t598 VSS 0.03305f
C8009 VDD.t1479 VSS 0.03468f
C8010 VDD.t600 VSS 0.03305f
C8011 VDD.t821 VSS 0.03468f
C8012 VDD.t920 VSS 0.03305f
C8013 VDD.t823 VSS 0.03468f
C8014 VDD.t921 VSS 0.03305f
C8015 VDD.t825 VSS 0.03468f
C8016 VDD.t922 VSS 0.03305f
C8017 VDD.t1575 VSS 0.03468f
C8018 VDD.t1459 VSS 0.03305f
C8019 VDD.t1576 VSS 0.03468f
C8020 VDD.t1461 VSS 0.03305f
C8021 VDD.t576 VSS 0.03468f
C8022 VDD.t1444 VSS 0.03305f
C8023 VDD.t574 VSS 0.03468f
C8024 VDD.t1442 VSS 0.03305f
C8025 VDD.t572 VSS 0.03468f
C8026 VDD.t1440 VSS 0.03305f
C8027 VDD.t1342 VSS 0.03468f
C8028 VDD.t1500 VSS 0.03305f
C8029 VDD.t1340 VSS 0.03468f
C8030 VDD.t1498 VSS 0.03305f
C8031 VDD.t1338 VSS 0.03468f
C8032 VDD.t1496 VSS 0.03305f
C8033 VDD.t354 VSS 0.03468f
C8034 VDD.t2078 VSS 0.03305f
C8035 VDD.t352 VSS 0.03468f
C8036 VDD.t2076 VSS 0.03305f
C8037 VDD.t350 VSS 0.03468f
C8038 VDD.t1443 VSS 0.29173f
C8039 VDD.t573 VSS 0.40091f
C8040 VDD.t1441 VSS 0.40091f
C8041 VDD.t571 VSS 0.40091f
C8042 VDD.t1439 VSS 0.40091f
C8043 VDD.t1341 VSS 0.40091f
C8044 VDD.t1499 VSS 0.40091f
C8045 VDD.t1339 VSS 0.40091f
C8046 VDD.t1497 VSS 0.40091f
C8047 VDD.t1337 VSS 0.40091f
C8048 VDD.t1495 VSS 0.40091f
C8049 VDD.t353 VSS 0.40091f
C8050 VDD.t2077 VSS 0.40091f
C8051 VDD.t351 VSS 0.30963f
C8052 VDD.t2075 VSS 0.1915f
C8053 VDD.t349 VSS 0.2094f
C8054 VDD.t2073 VSS 0.33048f
C8055 VDD.t2074 VSS 0.03305f
C8056 VDD.t483 VSS 0.03468f
C8057 VDD.t481 VSS 0.03468f
C8058 VDD.t479 VSS 0.03468f
C8059 VDD.t696 VSS 0.03468f
C8060 VDD.t968 VSS 0.03457f
C8061 VDD.t693 VSS 0.03468f
C8062 VDD.t926 VSS 0.03305f
C8063 VDD.t422 VSS 0.03468f
C8064 VDD.t928 VSS 0.04699f
C8065 VDD.n600 VSS 0.0262f
C8066 VDD.t420 VSS 0.03468f
C8067 VDD.t418 VSS 0.03468f
C8068 VDD.t2042 VSS 0.03305f
C8069 VDD.t2036 VSS 0.04699f
C8070 VDD.n603 VSS 0.0262f
C8071 VDD.t344 VSS 0.03468f
C8072 VDD.t1586 VSS 0.03457f
C8073 VDD.t2038 VSS 0.03305f
C8074 VDD.t564 VSS 0.03457f
C8075 VDD.n607 VSS 0.03527f
C8076 VDD.t1582 VSS 0.0378f
C8077 VDD.n610 VSS 0.04118f
C8078 VDD.t482 VSS 0.10023f
C8079 VDD.t1281 VSS 0.34721f
C8080 VDD.t1057 VSS 0.2273f
C8081 VDD.t480 VSS 0.38659f
C8082 VDD.t1278 VSS 0.40091f
C8083 VDD.t478 VSS 0.30007f
C8084 VDD.t694 VSS 0.14207f
C8085 VDD.n614 VSS 0.25719f
C8086 VDD.t1059 VSS 0.10739f
C8087 VDD.t695 VSS 0.13244f
C8088 VDD.t1276 VSS 0.2094f
C8089 VDD.t931 VSS 0.34274f
C8090 VDD.t1060 VSS 0.34364f
C8091 VDD.t967 VSS 0.15123f
C8092 VDD.t1280 VSS 0.10739f
C8093 VDD.t923 VSS 0.1915f
C8094 VDD.t692 VSS 0.22193f
C8095 VDD.t929 VSS 0.40091f
C8096 VDD.t421 VSS 0.31142f
C8097 VDD.t925 VSS 0.25952f
C8098 VDD.t927 VSS 0.32395f
C8099 VDD.t419 VSS 0.34185f
C8100 VDD.n620 VSS 0.30963f
C8101 VDD.t417 VSS 0.1915f
C8102 VDD.t2041 VSS 0.2094f
C8103 VDD.t343 VSS 0.3329f
C8104 VDD.t2035 VSS 0.2094f
C8105 VDD.t2037 VSS 0.16466f
C8106 VDD.t1585 VSS 0.31142f
C8107 VDD.t433 VSS 0.23625f
C8108 VDD.t2039 VSS 0.16466f
C8109 VDD.t563 VSS 0.1396f
C8110 VDD.t1365 VSS 0.27652f
C8111 VDD.t1368 VSS 0.4188f
C8112 VDD.t340 VSS 0.26757f
C8113 VDD.t1363 VSS 0.21477f
C8114 VDD.t159 VSS 0.18614f
C8115 VDD.t617 VSS 0.1396f
C8116 VDD.t1369 VSS 0.19866f
C8117 VDD.t1581 VSS 0.1721f
C8118 VDD.t342 VSS 0.14207f
C8119 VDD.n621 VSS 0.26793f
C8120 VDD.t1583 VSS 0.12797f
C8121 VDD.t1366 VSS 0.23446f
C8122 VDD.t1579 VSS 0.24341f
C8123 VDD.t1370 VSS 0.21835f
C8124 VDD.t1577 VSS 0.25594f
C8125 VDD.n622 VSS 0.10497f
C8126 VDD.t477 VSS 0.03468f
C8127 VDD.t616 VSS 0.03305f
C8128 VDD.t475 VSS 0.03468f
C8129 VDD.t615 VSS 0.03305f
C8130 VDD.t473 VSS 0.03468f
C8131 VDD.t1482 VSS 0.03305f
C8132 VDD.t1414 VSS 0.03468f
C8133 VDD.t1481 VSS 0.03305f
C8134 VDD.t1412 VSS 0.03468f
C8135 VDD.t1480 VSS 0.03305f
C8136 VDD.t1570 VSS 0.03305f
C8137 VDD.t1410 VSS 0.03468f
C8138 VDD.t624 VSS 0.03468f
C8139 VDD.n629 VSS 0.03507f
C8140 VDD.t622 VSS 0.03468f
C8141 VDD.n632 VSS 0.04118f
C8142 VDD.n633 VSS 0.03134f
C8143 VDD.t580 VSS 0.0378f
C8144 VDD.t1566 VSS 0.0278f
C8145 VDD.n635 VSS 0.04094f
C8146 VDD.t620 VSS 0.03468f
C8147 VDD.t234 VSS 0.03305f
C8148 VDD.t1463 VSS 0.03468f
C8149 VDD.t476 VSS 0.59241f
C8150 VDD.t474 VSS 0.80181f
C8151 VDD.t472 VSS 0.80181f
C8152 VDD.t1413 VSS 0.61031f
C8153 VDD.t1411 VSS 0.40091f
C8154 VDD.t1409 VSS 0.20045f
C8155 VDD.t1569 VSS 0.39196f
C8156 VDD.t623 VSS 0.23625f
C8157 VDD.t1567 VSS 0.39196f
C8158 VDD.t621 VSS 0.21477f
C8159 VDD.t1966 VSS 0.20224f
C8160 VDD.n643 VSS 0.20045f
C8161 VDD.t496 VSS 0.30247f
C8162 VDD.t1561 VSS 0.23446f
C8163 VDD.t577 VSS 0.20045f
C8164 VDD.t1563 VSS 0.20045f
C8165 VDD.t579 VSS 0.20045f
C8166 VDD.t1565 VSS 0.22014f
C8167 VDD.t235 VSS 0.1915f
C8168 VDD.t619 VSS 0.05727f
C8169 VDD.t233 VSS 0.29173f
C8170 VDD.t1462 VSS 0.2094f
C8171 VDD.n644 VSS 0.56929f
C8172 VDD.n651 VSS 0.05724f
C8173 VDD.n652 VSS 0.04937f
C8174 VDD.n653 VSS 0.06316f
C8175 VDD.n654 VSS 0.06033f
C8176 VDD.n655 VSS 1.61736f
C8177 VDD.t224 VSS 0.03305f
C8178 VDD.n657 VSS 0.03984f
C8179 VDD.t769 VSS 0.03468f
C8180 VDD.t226 VSS 0.03305f
C8181 VDD.t1624 VSS 0.03468f
C8182 VDD.t519 VSS 0.03305f
C8183 VDD.t1626 VSS 0.03468f
C8184 VDD.t521 VSS 0.03305f
C8185 VDD.t1628 VSS 0.03468f
C8186 VDD.t523 VSS 0.03305f
C8187 VDD.t608 VSS 0.03457f
C8188 VDD.t458 VSS 0.04699f
C8189 VDD.n662 VSS 0.0262f
C8190 VDD.t220 VSS 0.03468f
C8191 VDD.t454 VSS 0.03305f
C8192 VDD.t1083 VSS 0.10918f
C8193 VDD.t1084 VSS 0.03468f
C8194 VDD.t1426 VSS 0.03305f
C8195 VDD.t1082 VSS 0.03468f
C8196 VDD.t1424 VSS 0.03305f
C8197 VDD.t1080 VSS 0.03468f
C8198 VDD.t1422 VSS 0.03305f
C8199 VDD.t398 VSS 0.03468f
C8200 VDD.t1044 VSS 0.03305f
C8201 VDD.t1425 VSS 0.39196f
C8202 VDD.t1081 VSS 0.40091f
C8203 VDD.t1423 VSS 0.2094f
C8204 VDD.t1079 VSS 0.39196f
C8205 VDD.t1421 VSS 0.40091f
C8206 VDD.t397 VSS 0.40091f
C8207 VDD.t1043 VSS 0.2094f
C8208 VDD.n670 VSS 0.56929f
C8209 VDD.n677 VSS 0.03437f
C8210 VDD.n678 VSS 0.06221f
C8211 VDD.n679 VSS 0.05326f
C8212 VDD.n680 VSS 0.06221f
C8213 VDD.t765 VSS 0.03468f
C8214 VDD.t222 VSS 0.03305f
C8215 VDD.t767 VSS 0.03468f
C8216 VDD.n682 VSS 0.04332f
C8217 VDD.n683 VSS 0.03122f
C8218 VDD.n688 VSS 0.39196f
C8219 VDD.t764 VSS 0.2094f
C8220 VDD.t221 VSS 0.40091f
C8221 VDD.t766 VSS 0.40091f
C8222 VDD.t223 VSS 0.39196f
C8223 VDD.t768 VSS 0.2094f
C8224 VDD.t225 VSS 0.40091f
C8225 VDD.t1623 VSS 0.40091f
C8226 VDD.t518 VSS 0.40091f
C8227 VDD.t1625 VSS 0.40091f
C8228 VDD.t520 VSS 0.40091f
C8229 VDD.t1627 VSS 0.39196f
C8230 VDD.t522 VSS 0.10739f
C8231 VDD.t607 VSS 0.09307f
C8232 VDD.t457 VSS 0.30068f
C8233 VDD.t453 VSS 0.2094f
C8234 VDD.t219 VSS 0.26847f
C8235 VDD.t459 VSS 0.10918f
C8236 VDD.n689 VSS 0.25173f
C8237 VDD.t1636 VSS 0.03468f
C8238 VDD.t1638 VSS 0.03468f
C8239 VDD.t1640 VSS 0.03468f
C8240 VDD.t1574 VSS 0.03468f
C8241 VDD.t1490 VSS 0.04699f
C8242 VDD.n695 VSS 0.0262f
C8243 VDD.t1486 VSS 0.03305f
C8244 VDD.t1988 VSS 0.03305f
C8245 VDD.t467 VSS 0.03305f
C8246 VDD.t469 VSS 0.03305f
C8247 VDD.t471 VSS 0.03305f
C8248 VDD.t1194 VSS 0.03305f
C8249 VDD.t1196 VSS 0.03305f
C8250 VDD.t1198 VSS 0.03305f
C8251 VDD.t1056 VSS 0.03468f
C8252 VDD.t1379 VSS 0.03305f
C8253 VDD.t1317 VSS 0.03468f
C8254 VDD.t1381 VSS 0.03305f
C8255 VDD.t1319 VSS 0.03468f
C8256 VDD.t1383 VSS 0.03305f
C8257 VDD.t1321 VSS 0.03468f
C8258 VDD.t1434 VSS 0.03305f
C8259 VDD.t933 VSS 0.14233f
C8260 VDD.t1639 VSS 0.1721f
C8261 VDD.t611 VSS 0.14207f
C8262 VDD.t455 VSS 0.29173f
C8263 VDD.t614 VSS 0.2094f
C8264 VDD.t1635 VSS 0.25504f
C8265 VDD.t1986 VSS 0.31679f
C8266 VDD.t461 VSS 0.35169f
C8267 VDD.t1637 VSS 0.1933f
C8268 VDD.t609 VSS 0.24162f
C8269 VDD.t1985 VSS 0.19866f
C8270 VDD.n715 VSS 0.31625f
C8271 VDD.t612 VSS 0.26936f
C8272 VDD.t1573 VSS 0.3329f
C8273 VDD.t1983 VSS 0.23625f
C8274 VDD.t906 VSS 0.19687f
C8275 VDD.t1489 VSS 0.16466f
C8276 VDD.t1485 VSS 0.10023f
C8277 VDD.t1361 VSS 0.2094f
C8278 VDD.t1987 VSS 0.22193f
C8279 VDD.t1487 VSS 0.19508f
C8280 VDD.t1050 VSS 0.34542f
C8281 VDD.t466 VSS 0.25504f
C8282 VDD.t1054 VSS 0.1915f
C8283 VDD.n721 VSS 0.12528f
C8284 VDD.t1491 VSS 0.2094f
C8285 VDD.t1493 VSS 0.28457f
C8286 VDD.t468 VSS 0.13244f
C8287 VDD.t1053 VSS 0.10739f
C8288 VDD.n722 VSS 0.30491f
C8289 VDD.t470 VSS 0.29019f
C8290 VDD.t1048 VSS 0.40091f
C8291 VDD.t1193 VSS 0.38659f
C8292 VDD.t1051 VSS 0.2273f
C8293 VDD.t593 VSS 0.34721f
C8294 VDD.t1195 VSS 0.10023f
C8295 VDD.t1197 VSS 0.2094f
C8296 VDD.t1055 VSS 0.40091f
C8297 VDD.t1378 VSS 0.40091f
C8298 VDD.t1316 VSS 0.40091f
C8299 VDD.t1380 VSS 0.40091f
C8300 VDD.t1318 VSS 0.40091f
C8301 VDD.t1382 VSS 0.40091f
C8302 VDD.t1320 VSS 0.29173f
C8303 VDD.t1433 VSS 0.43965f
C8304 VDD.t1092 VSS 0.03468f
C8305 VDD.t1436 VSS 0.03305f
C8306 VDD.t1094 VSS 0.03468f
C8307 VDD.t1438 VSS 0.03305f
C8308 VDD.t1356 VSS 0.03468f
C8309 VDD.t1116 VSS 0.03305f
C8310 VDD.t1358 VSS 0.03468f
C8311 VDD.t1118 VSS 0.03305f
C8312 VDD.t1360 VSS 0.03468f
C8313 VDD.t1120 VSS 0.03305f
C8314 VDD.t1074 VSS 0.03468f
C8315 VDD.t1690 VSS 0.03305f
C8316 VDD.t1076 VSS 0.03468f
C8317 VDD.t1692 VSS 0.03305f
C8318 VDD.t1078 VSS 0.03468f
C8319 VDD.t1694 VSS 0.03305f
C8320 VDD.t679 VSS 0.03468f
C8321 VDD.t681 VSS 0.03468f
C8322 VDD.t1028 VSS 0.03305f
C8323 VDD.t683 VSS 0.03468f
C8324 VDD.t1029 VSS 0.03305f
C8325 VDD.t1466 VSS 0.03468f
C8326 VDD.t1031 VSS 0.03305f
C8327 VDD.t1467 VSS 0.03468f
C8328 VDD.t962 VSS 0.03305f
C8329 VDD.t1468 VSS 0.03468f
C8330 VDD.t964 VSS 0.03305f
C8331 VDD.t1713 VSS 0.03468f
C8332 VDD.t966 VSS 0.03305f
C8333 VDD.t1715 VSS 0.03468f
C8334 VDD.t1847 VSS 0.03305f
C8335 VDD.t1717 VSS 0.03468f
C8336 VDD.t1848 VSS 0.03305f
C8337 VDD.t1091 VSS 0.40091f
C8338 VDD.t1435 VSS 0.1915f
C8339 VDD.t1093 VSS 0.30963f
C8340 VDD.t1437 VSS 0.40091f
C8341 VDD.t1355 VSS 0.40091f
C8342 VDD.t1115 VSS 0.40091f
C8343 VDD.t1357 VSS 0.40091f
C8344 VDD.t1117 VSS 0.40091f
C8345 VDD.t1359 VSS 0.40091f
C8346 VDD.t1119 VSS 0.40091f
C8347 VDD.t1073 VSS 0.40091f
C8348 VDD.t1689 VSS 0.40091f
C8349 VDD.t1075 VSS 0.40091f
C8350 VDD.t1691 VSS 0.40091f
C8351 VDD.t1077 VSS 0.40091f
C8352 VDD.t1693 VSS 0.29173f
C8353 VDD.t678 VSS 0.30068f
C8354 VDD.t680 VSS 0.61031f
C8355 VDD.t682 VSS 0.80181f
C8356 VDD.t1030 VSS 0.80181f
C8357 VDD.t961 VSS 0.80181f
C8358 VDD.t963 VSS 0.80181f
C8359 VDD.t965 VSS 0.80181f
C8360 VDD.t1714 VSS 0.80181f
C8361 VDD.t1716 VSS 0.59241f
C8362 VDD.n746 VSS 0.48696f
C8363 VDD.n753 VSS 0.09437f
C8364 VDD.n754 VSS 0.03122f
C8365 VDD.n755 VSS 0.06221f
C8366 VDD.n756 VSS 0.06221f
C8367 VDD.n757 VSS 0.06221f
C8368 VDD.n758 VSS 0.06221f
C8369 VDD.n759 VSS 0.06221f
C8370 VDD.n760 VSS 0.06221f
C8371 VDD.n761 VSS 0.06221f
C8372 VDD.n762 VSS 0.05326f
C8373 VDD.n763 VSS 0.05326f
C8374 VDD.n764 VSS 0.06221f
C8375 VDD.n765 VSS 0.06221f
C8376 VDD.n766 VSS 0.06221f
C8377 VDD.n767 VSS 0.03437f
C8378 VDD.n768 VSS 0.04332f
C8379 VDD.n769 VSS 0.05475f
C8380 VDD.n770 VSS 0.13855f
C8381 VDD.n771 VSS 0.03167f
C8382 VDD.n772 VSS 0.03507f
C8383 VDD.t1157 VSS 0.0278f
C8384 VDD.n774 VSS 0.04127f
C8385 VDD.t2044 VSS 0.03305f
C8386 VDD.t2046 VSS 0.03305f
C8387 VDD.t1106 VSS 0.03468f
C8388 VDD.t2048 VSS 0.03305f
C8389 VDD.t1332 VSS 0.03468f
C8390 VDD.t1630 VSS 0.03305f
C8391 VDD.t1334 VSS 0.03468f
C8392 VDD.t1632 VSS 0.03305f
C8393 VDD.t1336 VSS 0.03468f
C8394 VDD.t1634 VSS 0.03305f
C8395 VDD.t1154 VSS 0.2452f
C8396 VDD.t1155 VSS 0.0278f
C8397 VDD.n783 VSS 0.04127f
C8398 VDD.t759 VSS 0.03305f
C8399 VDD.t1104 VSS 0.03468f
C8400 VDD.t1392 VSS 0.03305f
C8401 VDD.t1102 VSS 0.03468f
C8402 VDD.t1390 VSS 0.03305f
C8403 VDD.t1456 VSS 0.03468f
C8404 VDD.t1388 VSS 0.03305f
C8405 VDD.t1454 VSS 0.03468f
C8406 VDD.t1114 VSS 0.03305f
C8407 VDD.t1452 VSS 0.03468f
C8408 VDD.t1112 VSS 0.03305f
C8409 VDD.t570 VSS 0.03468f
C8410 VDD.t1110 VSS 0.03305f
C8411 VDD.n791 VSS 0.03527f
C8412 VDD.t1148 VSS 0.29173f
C8413 VDD.t758 VSS 0.10023f
C8414 VDD.t1103 VSS 0.1915f
C8415 VDD.t1391 VSS 0.40091f
C8416 VDD.t1101 VSS 0.40091f
C8417 VDD.t1389 VSS 0.40091f
C8418 VDD.t1455 VSS 0.40091f
C8419 VDD.t1387 VSS 0.40091f
C8420 VDD.t1453 VSS 0.40091f
C8421 VDD.t1113 VSS 0.2094f
C8422 VDD.t1451 VSS 0.1915f
C8423 VDD.t1111 VSS 0.40091f
C8424 VDD.t569 VSS 0.40091f
C8425 VDD.t1109 VSS 0.30963f
C8426 VDD.t567 VSS 0.16466f
C8427 VDD.t1292 VSS 0.21477f
C8428 VDD.t1849 VSS 0.12886f
C8429 VDD.t986 VSS 0.19866f
C8430 VDD.n794 VSS 0.28394f
C8431 VDD.t1704 VSS 0.0278f
C8432 VDD.n796 VSS 0.04127f
C8433 VDD.n797 VSS 0.03167f
C8434 VDD.n800 VSS 0.03167f
C8435 VDD.t1702 VSS 0.0278f
C8436 VDD.n803 VSS 0.04127f
C8437 VDD.t1604 VSS 0.03305f
C8438 VDD.t1377 VSS 0.03468f
C8439 VDD.t1606 VSS 0.04699f
C8440 VDD.n805 VSS 0.0262f
C8441 VDD.t1375 VSS 0.03468f
C8442 VDD.t1600 VSS 0.03305f
C8443 VDD.t1373 VSS 0.03468f
C8444 VDD.t1598 VSS 0.03305f
C8445 VDD.t1348 VSS 0.03468f
C8446 VDD.t1204 VSS 0.03305f
C8447 VDD.t1346 VSS 0.03468f
C8448 VDD.t1202 VSS 0.03305f
C8449 VDD.t1344 VSS 0.03468f
C8450 VDD.t1200 VSS 0.03305f
C8451 VDD.t1330 VSS 0.03468f
C8452 VDD.t2056 VSS 0.03305f
C8453 VDD.t1328 VSS 0.03468f
C8454 VDD.t1710 VSS 0.14676f
C8455 VDD.t565 VSS 0.12797f
C8456 VDD.t1703 VSS 0.1721f
C8457 VDD.t1709 VSS 0.14207f
C8458 VDD.n814 VSS 0.30193f
C8459 VDD.t988 VSS 0.09665f
C8460 VDD.t1705 VSS 0.13244f
C8461 VDD.t1071 VSS 0.20045f
C8462 VDD.t1707 VSS 0.1933f
C8463 VDD.t1069 VSS 0.36243f
C8464 VDD.t989 VSS 0.32753f
C8465 VDD.t1697 VSS 0.25504f
C8466 VDD.t1712 VSS 0.20045f
C8467 VDD.t1699 VSS 0.1396f
C8468 VDD.t1601 VSS 0.20045f
C8469 VDD.t1701 VSS 0.22193f
C8470 VDD.t1067 VSS 0.23446f
C8471 VDD.t1695 VSS 0.13602f
C8472 VDD.t1603 VSS 0.1915f
C8473 VDD.t1376 VSS 0.18256f
C8474 VDD.t1605 VSS 0.30963f
C8475 VDD.t1374 VSS 0.1915f
C8476 VDD.t1599 VSS 0.40091f
C8477 VDD.t1372 VSS 0.40091f
C8478 VDD.t1597 VSS 0.40091f
C8479 VDD.t1347 VSS 0.40986f
C8480 VDD.t1203 VSS 0.29173f
C8481 VDD.t1345 VSS 0.40091f
C8482 VDD.t1201 VSS 0.40091f
C8483 VDD.t1343 VSS 0.40091f
C8484 VDD.t1199 VSS 0.40091f
C8485 VDD.t1329 VSS 0.40091f
C8486 VDD.t2055 VSS 0.40091f
C8487 VDD.t1327 VSS 0.2094f
C8488 VDD.n819 VSS 0.56929f
C8489 VDD.n826 VSS 0.05724f
C8490 VDD.n827 VSS 0.06221f
C8491 VDD.n828 VSS 0.06221f
C8492 VDD.n829 VSS 0.06221f
C8493 VDD.n830 VSS 0.03122f
C8494 VDD.n831 VSS 0.0294f
C8495 VDD.n832 VSS 0.06221f
C8496 VDD.n833 VSS 0.0715f
C8497 VDD.n834 VSS 0.02701f
C8498 VDD.n835 VSS 0.03845f
C8499 VDD.n836 VSS 0.06455f
C8500 VDD.n837 VSS 0.05062f
C8501 VDD.n838 VSS 0.03683f
C8502 VDD.n839 VSS 0.04292f
C8503 VDD.n841 VSS 0.06221f
C8504 VDD.n843 VSS 0.06221f
C8505 VDD.n844 VSS 0.06221f
C8506 VDD.n845 VSS 0.06221f
C8507 VDD.n847 VSS 0.03167f
C8508 VDD.n848 VSS 0.03507f
C8509 VDD.n850 VSS 0.04914f
C8510 VDD.n851 VSS 0.03122f
C8511 VDD.n856 VSS 0.20045f
C8512 VDD.t1152 VSS 0.31321f
C8513 VDD.t760 VSS 0.20045f
C8514 VDD.t1150 VSS 0.21477f
C8515 VDD.t1862 VSS 0.30247f
C8516 VDD.t1160 VSS 0.07517f
C8517 VDD.t244 VSS 0.20045f
C8518 VDD.t1158 VSS 0.21477f
C8519 VDD.t762 VSS 0.20045f
C8520 VDD.t1156 VSS 0.35795f
C8521 VDD.t969 VSS 0.28994f
C8522 VDD.t2043 VSS 0.14676f
C8523 VDD.t2045 VSS 0.2094f
C8524 VDD.t1105 VSS 0.1915f
C8525 VDD.t2047 VSS 0.30963f
C8526 VDD.t1331 VSS 0.40091f
C8527 VDD.t1629 VSS 0.40091f
C8528 VDD.t1333 VSS 0.40091f
C8529 VDD.t1631 VSS 0.40091f
C8530 VDD.t1335 VSS 0.29173f
C8531 VDD.t1633 VSS 0.33048f
C8532 VDD.t426 VSS 0.03468f
C8533 VDD.t829 VSS 0.03305f
C8534 VDD.t841 VSS 0.03468f
C8535 VDD.t831 VSS 0.03305f
C8536 VDD.t843 VSS 0.03468f
C8537 VDD.t833 VSS 0.03305f
C8538 VDD.t845 VSS 0.03468f
C8539 VDD.t552 VSS 0.03305f
C8540 VDD.t972 VSS 0.03468f
C8541 VDD.t554 VSS 0.03305f
C8542 VDD.t974 VSS 0.03468f
C8543 VDD.t556 VSS 0.03305f
C8544 VDD.t976 VSS 0.03468f
C8545 VDD.t1144 VSS 0.03305f
C8546 VDD.t428 VSS 0.03468f
C8547 VDD.t1146 VSS 0.03305f
C8548 VDD.t430 VSS 0.03468f
C8549 VDD.t432 VSS 0.03468f
C8550 VDD.t1147 VSS 0.03305f
C8551 VDD.t1469 VSS 0.03468f
C8552 VDD.t815 VSS 0.03305f
C8553 VDD.t1470 VSS 0.03468f
C8554 VDD.t817 VSS 0.03305f
C8555 VDD.t1471 VSS 0.03468f
C8556 VDD.t819 VSS 0.03305f
C8557 VDD.t1384 VSS 0.03468f
C8558 VDD.t1214 VSS 0.03305f
C8559 VDD.t1385 VSS 0.03468f
C8560 VDD.t1216 VSS 0.03305f
C8561 VDD.t1386 VSS 0.03468f
C8562 VDD.t1218 VSS 0.03305f
C8563 VDD.t1108 VSS 0.03468f
C8564 VDD.t1326 VSS 0.03305f
C8565 VDD.t425 VSS 0.2094f
C8566 VDD.t828 VSS 0.1915f
C8567 VDD.t840 VSS 0.30963f
C8568 VDD.t830 VSS 0.40091f
C8569 VDD.t842 VSS 0.40091f
C8570 VDD.t832 VSS 0.40091f
C8571 VDD.t844 VSS 0.40091f
C8572 VDD.t551 VSS 0.40091f
C8573 VDD.t971 VSS 0.40091f
C8574 VDD.t553 VSS 0.40091f
C8575 VDD.t973 VSS 0.40091f
C8576 VDD.t555 VSS 0.40091f
C8577 VDD.t975 VSS 0.40091f
C8578 VDD.t1143 VSS 0.40091f
C8579 VDD.t427 VSS 0.40091f
C8580 VDD.t1145 VSS 0.29173f
C8581 VDD.t429 VSS 0.30068f
C8582 VDD.t431 VSS 0.61031f
C8583 VDD.t814 VSS 0.80181f
C8584 VDD.t816 VSS 0.80181f
C8585 VDD.t818 VSS 0.80181f
C8586 VDD.t1213 VSS 0.80181f
C8587 VDD.t1215 VSS 0.80181f
C8588 VDD.t1217 VSS 0.80181f
C8589 VDD.t1107 VSS 0.59241f
C8590 VDD.n879 VSS 0.48696f
C8591 VDD.t1654 VSS 0.03305f
C8592 VDD.n887 VSS 0.06022f
C8593 VDD.t1656 VSS 0.03305f
C8594 VDD.t1519 VSS 0.03305f
C8595 VDD.t1521 VSS 0.03305f
C8596 VDD.t1523 VSS 0.03305f
C8597 VDD.t771 VSS 0.03305f
C8598 VDD.t773 VSS 0.03305f
C8599 VDD.t1651 VSS 0.24143f
C8600 VDD.t1652 VSS 0.03305f
C8601 VDD.t1100 VSS 0.03305f
C8602 VDD.t1098 VSS 0.03305f
C8603 VDD.t1096 VSS 0.03305f
C8604 VDD.t218 VSS 0.03305f
C8605 VDD.t216 VSS 0.03305f
C8606 VDD.t214 VSS 0.03305f
C8607 VDD.t1867 VSS 0.03305f
C8608 VDD.t1865 VSS 0.03305f
C8609 VDD.t410 VSS 0.03305f
C8610 VDD.t408 VSS 0.03305f
C8611 VDD.t406 VSS 0.03305f
C8612 VDD.t652 VSS 0.03305f
C8613 VDD.t650 VSS 0.03305f
C8614 VDD.t648 VSS 0.03305f
C8615 VDD.t2054 VSS 0.03305f
C8616 VDD.t2052 VSS 0.03305f
C8617 VDD.t2050 VSS 0.03305f
C8618 VDD.n920 VSS 0.03507f
C8619 VDD.t1539 VSS 0.03305f
C8620 VDD.t1537 VSS 0.03305f
C8621 VDD.t677 VSS 0.03305f
C8622 VDD.t675 VSS 0.03305f
C8623 VDD.t673 VSS 0.03305f
C8624 VDD.t1982 VSS 0.03305f
C8625 VDD.t1980 VSS 0.03305f
C8626 VDD.t1978 VSS 0.03305f
C8627 VDD.t1866 VSS 0.35517f
C8628 VDD.t1864 VSS 0.48072f
C8629 VDD.t409 VSS 0.48072f
C8630 VDD.t407 VSS 0.48072f
C8631 VDD.t405 VSS 0.48072f
C8632 VDD.t651 VSS 0.48072f
C8633 VDD.t649 VSS 0.48072f
C8634 VDD.t647 VSS 0.42063f
C8635 VDD.n940 VSS 0.24572f
C8636 VDD.t2053 VSS 0.35517f
C8637 VDD.t2051 VSS 0.3659f
C8638 VDD.t2049 VSS 0.24036f
C8639 VDD.t1540 VSS 0.31118f
C8640 VDD.t1845 VSS 0.17383f
C8641 VDD.t1538 VSS 0.35517f
C8642 VDD.t1536 VSS 0.3659f
C8643 VDD.t676 VSS 0.24036f
C8644 VDD.n946 VSS 0.18027f
C8645 VDD.t674 VSS 0.35517f
C8646 VDD.t672 VSS 0.48072f
C8647 VDD.t1981 VSS 0.48072f
C8648 VDD.t1979 VSS 0.3659f
C8649 VDD.t1977 VSS 0.24036f
C8650 VDD.n947 VSS 0.38522f
C8651 VDD.n949 VSS 0.0382f
C8652 VDD.n950 VSS 0.06221f
C8653 VDD.n951 VSS 0.07116f
C8654 VDD.n952 VSS 0.11789f
C8655 VDD.n953 VSS 0.11789f
C8656 VDD.n954 VSS 0.10894f
C8657 VDD.n955 VSS 0.03122f
C8658 VDD.n957 VSS 0.13855f
C8659 VDD.n958 VSS 0.07116f
C8660 VDD.n959 VSS 0.10894f
C8661 VDD.n960 VSS 0.08817f
C8662 VDD.n961 VSS 0.06221f
C8663 VDD.n962 VSS 0.07116f
C8664 VDD.n963 VSS 0.10894f
C8665 VDD.n964 VSS 0.03122f
C8666 VDD.n965 VSS 0.07116f
C8667 VDD.n966 VSS 0.11789f
C8668 VDD.n967 VSS 0.11789f
C8669 VDD.n968 VSS 0.11789f
C8670 VDD.n969 VSS 0.11789f
C8671 VDD.n970 VSS 0.11789f
C8672 VDD.n971 VSS 0.11789f
C8673 VDD.n972 VSS 0.10894f
C8674 VDD.t1869 VSS 0.03305f
C8675 VDD.n974 VSS 0.0545f
C8676 VDD.n975 VSS 0.03122f
C8677 VDD.n980 VSS 0.24572f
C8678 VDD.t1868 VSS 0.29508f
C8679 VDD.t1871 VSS 0.3659f
C8680 VDD.t1873 VSS 0.35517f
C8681 VDD.t1875 VSS 0.23607f
C8682 VDD.t1008 VSS 0.3659f
C8683 VDD.t1010 VSS 0.35517f
C8684 VDD.t1012 VSS 0.23607f
C8685 VDD.t1099 VSS 0.24036f
C8686 VDD.t1097 VSS 0.23607f
C8687 VDD.t1095 VSS 0.35517f
C8688 VDD.t217 VSS 0.3659f
C8689 VDD.t215 VSS 0.23607f
C8690 VDD.t213 VSS 0.29508f
C8691 VDD.n983 VSS 0.24572f
C8692 VDD.t1013 VSS 0.03305f
C8693 VDD.t1011 VSS 0.03305f
C8694 VDD.t1009 VSS 0.03305f
C8695 VDD.t1876 VSS 0.03305f
C8696 VDD.t1874 VSS 0.03305f
C8697 VDD.t1872 VSS 0.03305f
C8698 VDD.n992 VSS 0.07116f
C8699 VDD.n993 VSS 0.10894f
C8700 VDD.n994 VSS 0.06259f
C8701 VDD.n995 VSS 0.07116f
C8702 VDD.n996 VSS 0.10894f
C8703 VDD.n997 VSS 0.06259f
C8704 VDD.n998 VSS 0.03122f
C8705 VDD.n999 VSS 0.06221f
C8706 VDD.n1000 VSS 0.06259f
C8707 VDD.n1001 VSS 0.07116f
C8708 VDD.n1002 VSS 0.10894f
C8709 VDD.n1003 VSS 0.06259f
C8710 VDD.n1004 VSS 0.06221f
C8711 VDD.n1005 VSS 0.06259f
C8712 VDD.n1006 VSS 0.03122f
C8713 VDD.n1011 VSS 0.32137f
C8714 VDD.t1653 VSS 0.3659f
C8715 VDD.t1655 VSS 0.35517f
C8716 VDD.t1518 VSS 0.23607f
C8717 VDD.t1520 VSS 0.3659f
C8718 VDD.t1522 VSS 0.35517f
C8719 VDD.t770 VSS 0.29616f
C8720 VDD.t772 VSS 0.24358f
C8721 VDD.n1012 VSS 0.41687f
C8722 VDD.n1018 VSS 0.03122f
C8723 VDD.n1019 VSS 0.06259f
C8724 VDD.n1020 VSS 0.06259f
C8725 VDD.n1021 VSS 0.10894f
C8726 VDD.n1022 VSS 0.07116f
C8727 VDD.n1023 VSS 0.06259f
C8728 VDD.n1024 VSS 0.0642f
C8729 VDD.n1025 VSS 0.1475f
C8730 VDD.n1026 VSS 1.61736f
C8731 VDD.n1027 VSS 0.09437f
C8732 VDD.n1028 VSS 0.03122f
C8733 VDD.n1029 VSS 0.06221f
C8734 VDD.n1030 VSS 0.06221f
C8735 VDD.n1031 VSS 0.06221f
C8736 VDD.n1032 VSS 0.06221f
C8737 VDD.n1033 VSS 0.06221f
C8738 VDD.n1034 VSS 0.06221f
C8739 VDD.n1035 VSS 0.06221f
C8740 VDD.n1036 VSS 0.04829f
C8741 VDD.n1037 VSS 0.05326f
C8742 VDD.n1038 VSS 0.06221f
C8743 VDD.n1039 VSS 0.06221f
C8744 VDD.n1040 VSS 0.0294f
C8745 VDD.n1041 VSS 0.03437f
C8746 VDD.n1042 VSS 0.04083f
C8747 VDD.n1043 VSS 0.0576f
C8748 VDD.n1044 VSS 0.06927f
C8749 VDD.n1045 VSS 1.61736f
C8750 VDD.n1046 VSS 1.07521f
C8751 VDD.n1047 VSS 0.08393f
C8752 VDD.n1048 VSS 0.04058f
C8753 VDD.n1049 VSS 0.06121f
C8754 VDD.n1050 VSS 0.03122f
C8755 VDD.n1051 VSS 0.10049f
C8756 VDD.n1053 VSS 0.04739f
C8757 VDD.n1054 VSS 0.04926f
C8758 VDD.n1055 VSS 0.06181f
C8759 VDD.n1057 VSS 0.05088f
C8760 VDD.n1058 VSS 0.03199f
C8761 VDD.n1059 VSS 0.05326f
C8762 VDD.n1060 VSS 0.06221f
C8763 VDD.n1061 VSS 0.06221f
C8764 VDD.n1062 VSS 0.04332f
C8765 VDD.n1063 VSS 0.06653f
C8766 VDD.n1064 VSS 1.07521f
C8767 VDD.n1065 VSS 1.07521f
C8768 VDD.n1066 VSS 0.07548f
C8769 VDD.n1067 VSS 0.02504f
C8770 VDD.n1068 VSS 0.03397f
C8771 VDD.n1069 VSS 0.04168f
C8772 VDD.n1070 VSS 0.04292f
C8773 VDD.n1072 VSS 0.04839f
C8774 VDD.n1073 VSS 0.03696f
C8775 VDD.n1075 VSS 0.02625f
C8776 VDD.n1076 VSS 0.05486f
C8777 VDD.n1077 VSS 0.04317f
C8778 VDD.n1078 VSS 0.07349f
C8779 VDD.n1079 VSS 0.05088f
C8780 VDD.n1081 VSS 0.05821f
C8781 VDD.n1082 VSS 0.06181f
C8782 VDD.n1084 VSS 0.04829f
C8783 VDD.n1085 VSS 0.06221f
C8784 VDD.n1086 VSS 0.06221f
C8785 VDD.n1087 VSS 0.06221f
C8786 VDD.n1088 VSS 0.06221f
C8787 VDD.n1089 VSS 0.06221f
C8788 VDD.n1090 VSS 0.06221f
C8789 VDD.n1091 VSS 0.06221f
C8790 VDD.t1477 VSS 0.03468f
C8791 VDD.t596 VSS 0.03305f
C8792 VDD.n1093 VSS 0.03122f
C8793 VDD.t575 VSS 0.30068f
C8794 VDD.t595 VSS 0.61031f
C8795 VDD.t597 VSS 0.80181f
C8796 VDD.t599 VSS 0.80181f
C8797 VDD.t820 VSS 0.80181f
C8798 VDD.t822 VSS 0.80181f
C8799 VDD.t824 VSS 0.80181f
C8800 VDD.t1458 VSS 0.80181f
C8801 VDD.t1460 VSS 0.59241f
C8802 VDD.n1098 VSS 0.48696f
C8803 VDD.n1105 VSS 0.09437f
C8804 VDD.n1106 VSS 1.07521f
C8805 VDD.n1107 VSS 1.07521f
C8806 VDD.n1108 VSS 0.09437f
C8807 VDD.n1109 VSS 0.03122f
C8808 VDD.n1110 VSS 0.06221f
C8809 VDD.n1111 VSS 0.06221f
C8810 VDD.n1112 VSS 0.06221f
C8811 VDD.n1113 VSS 0.05724f
C8812 VDD.n1114 VSS 0.06221f
C8813 VDD.n1115 VSS 0.05724f
C8814 VDD.n1117 VSS 0.04677f
C8815 VDD.n1118 VSS 0.06653f
C8816 VDD.n1120 VSS 0.05088f
C8817 VDD.n1122 VSS 0.02724f
C8818 VDD.n1123 VSS 0.06728f
C8819 VDD.n1124 VSS 1.07521f
C8820 VDD.n1125 VSS 1.07521f
C8821 VDD.n1126 VSS 0.08642f
C8822 VDD.n1127 VSS 0.08342f
C8823 VDD.n1129 VSS 0.10894f
C8824 VDD.n1130 VSS 0.06768f
C8825 VDD.n1131 VSS 0.0637f
C8826 VDD.n1133 VSS 0.05077f
C8827 VDD.n1134 VSS 0.05326f
C8828 VDD.n1135 VSS 0.06221f
C8829 VDD.n1136 VSS 0.06221f
C8830 VDD.n1137 VSS 0.06221f
C8831 VDD.n1138 VSS 0.06221f
C8832 VDD.n1139 VSS 0.06221f
C8833 VDD.n1140 VSS 0.04282f
C8834 VDD.n1141 VSS 0.08045f
C8835 VDD.n1142 VSS 1.07521f
C8836 VDD.n1143 VSS 1.07521f
C8837 VDD.n1144 VSS 0.08045f
C8838 VDD.n1145 VSS 0.04282f
C8839 VDD.n1146 VSS 0.06221f
C8840 VDD.n1147 VSS 0.06221f
C8841 VDD.n1148 VSS 0.06221f
C8842 VDD.n1149 VSS 0.06221f
C8843 VDD.n1150 VSS 0.06221f
C8844 VDD.n1151 VSS 0.05326f
C8845 VDD.n1152 VSS 0.03437f
C8846 VDD.n1153 VSS 0.05326f
C8847 VDD.n1154 VSS 0.06221f
C8848 VDD.n1155 VSS 0.06221f
C8849 VDD.n1156 VSS 0.06221f
C8850 VDD.n1157 VSS 0.06221f
C8851 VDD.n1158 VSS 0.06221f
C8852 VDD.n1159 VSS 0.06221f
C8853 VDD.n1160 VSS 0.03122f
C8854 VDD.n1161 VSS 0.04058f
C8855 VDD.n1162 VSS 0.07399f
C8856 VDD.n1164 VSS 0.06221f
C8857 VDD.n1165 VSS 0.05326f
C8858 VDD.n1166 VSS 0.06221f
C8859 VDD.n1167 VSS 0.06221f
C8860 VDD.n1168 VSS 0.06221f
C8861 VDD.n1169 VSS 0.05326f
C8862 VDD.n1170 VSS 0.05326f
C8863 VDD.n1171 VSS 0.06221f
C8864 VDD.n1172 VSS 0.06221f
C8865 VDD.n1173 VSS 0.06221f
C8866 VDD.n1174 VSS 0.06221f
C8867 VDD.n1175 VSS 0.06221f
C8868 VDD.n1176 VSS 0.06221f
C8869 VDD.n1177 VSS 0.06221f
C8870 VDD.t1657 VSS 0.03468f
C8871 VDD.t779 VSS 0.03305f
C8872 VDD.n1179 VSS 0.03122f
C8873 VDD.t1559 VSS 0.30068f
C8874 VDD.t778 VSS 0.61031f
C8875 VDD.t1524 VSS 0.80181f
C8876 VDD.t1526 VSS 0.80181f
C8877 VDD.t1322 VSS 0.80181f
C8878 VDD.t1162 VSS 0.80181f
C8879 VDD.t1164 VSS 0.80181f
C8880 VDD.t810 VSS 0.80181f
C8881 VDD.t812 VSS 0.59241f
C8882 VDD.n1184 VSS 0.48696f
C8883 VDD.n1191 VSS 0.09437f
C8884 VDD.n1192 VSS 1.07521f
C8885 VDD.t1784 VSS 0.03468f
C8886 VDD.t107 VSS 0.03305f
C8887 VDD.t863 VSS 0.03468f
C8888 VDD.t73 VSS 0.03305f
C8889 VDD.t872 VSS 0.03468f
C8890 VDD.t346 VSS 0.03305f
C8891 VDD.t1206 VSS 0.03468f
C8892 VDD.t2007 VSS 0.03305f
C8893 VDD.t1912 VSS 0.03468f
C8894 VDD.t103 VSS 0.03305f
C8895 VDD.t118 VSS 0.03468f
C8896 VDD.t21 VSS 0.03305f
C8897 VDD.t2019 VSS 0.03468f
C8898 VDD.t1787 VSS 0.03305f
C8899 VDD.t1751 VSS 0.03468f
C8900 VDD.t25 VSS 0.03305f
C8901 VDD.t53 VSS 0.03468f
C8902 VDD.t503 VSS 0.03305f
C8903 VDD.t59 VSS 0.03468f
C8904 VDD.t75 VSS 0.03305f
C8905 VDD.t1747 VSS 0.03468f
C8906 VDD.t787 VSS 0.03305f
C8907 VDD.t378 VSS 0.03468f
C8908 VDD.t1763 VSS 0.03305f
C8909 VDD.t1927 VSS 0.03468f
C8910 VDD.t140 VSS 0.03305f
C8911 VDD.t328 VSS 0.03468f
C8912 VDD.t87 VSS 0.03305f
C8913 VDD.t795 VSS 0.03468f
C8914 VDD.t752 VSS 0.03305f
C8915 VDD.t1731 VSS 0.03468f
C8916 VDD.t2103 VSS 0.40091f
C8917 VDD.t143 VSS 0.1915f
C8918 VDD.t859 VSS 0.30963f
C8919 VDD.t307 VSS 0.40091f
C8920 VDD.t861 VSS 0.40091f
C8921 VDD.t1896 VSS 0.40091f
C8922 VDD.t2008 VSS 0.40091f
C8923 VDD.t121 VSS 0.40091f
C8924 VDD.t2010 VSS 0.40091f
C8925 VDD.t94 VSS 0.40091f
C8926 VDD.t855 VSS 0.40091f
C8927 VDD.t1774 VSS 0.40091f
C8928 VDD.t857 VSS 0.40091f
C8929 VDD.t141 VSS 0.40091f
C8930 VDD.t62 VSS 0.40091f
C8931 VDD.t325 VSS 0.29173f
C8932 VDD.t64 VSS 0.40986f
C8933 VDD.t303 VSS 0.40091f
C8934 VDD.t2012 VSS 0.1915f
C8935 VDD.t84 VSS 0.30963f
C8936 VDD.t2014 VSS 0.40091f
C8937 VDD.t1960 VSS 0.40091f
C8938 VDD.t1829 VSS 0.40091f
C8939 VDD.t365 VSS 0.40091f
C8940 VDD.t1831 VSS 0.40091f
C8941 VDD.t82 VSS 0.40091f
C8942 VDD.t1770 VSS 0.40091f
C8943 VDD.t1922 VSS 0.40091f
C8944 VDD.t1772 VSS 0.40091f
C8945 VDD.t1243 VSS 0.40091f
C8946 VDD.t1744 VSS 0.40091f
C8947 VDD.t369 VSS 0.40091f
C8948 VDD.t1955 VSS 0.29173f
C8949 VDD.t24 VSS 0.29173f
C8950 VDD.t52 VSS 0.40091f
C8951 VDD.t502 VSS 0.40091f
C8952 VDD.t58 VSS 0.40091f
C8953 VDD.t74 VSS 0.40091f
C8954 VDD.t1746 VSS 0.40091f
C8955 VDD.t786 VSS 0.40091f
C8956 VDD.t377 VSS 0.40091f
C8957 VDD.t1762 VSS 0.40091f
C8958 VDD.t1926 VSS 0.40091f
C8959 VDD.t139 VSS 0.40091f
C8960 VDD.t327 VSS 0.40091f
C8961 VDD.t86 VSS 0.40091f
C8962 VDD.t794 VSS 0.30963f
C8963 VDD.t751 VSS 0.1915f
C8964 VDD.t1730 VSS 0.40091f
C8965 VDD.t1900 VSS 0.43965f
C8966 VDD.t1901 VSS 0.03305f
C8967 VDD.t1956 VSS 0.03468f
C8968 VDD.t370 VSS 0.03305f
C8969 VDD.t1745 VSS 0.03468f
C8970 VDD.t1244 VSS 0.03305f
C8971 VDD.t1773 VSS 0.03468f
C8972 VDD.t1923 VSS 0.03305f
C8973 VDD.t1771 VSS 0.03468f
C8974 VDD.t83 VSS 0.03305f
C8975 VDD.t1832 VSS 0.03468f
C8976 VDD.t366 VSS 0.03305f
C8977 VDD.t1830 VSS 0.03468f
C8978 VDD.n1221 VSS 0.06221f
C8979 VDD.n1222 VSS 0.06221f
C8980 VDD.n1223 VSS 0.06221f
C8981 VDD.n1224 VSS 0.06221f
C8982 VDD.n1225 VSS 0.06221f
C8983 VDD.n1226 VSS 0.05326f
C8984 VDD.n1227 VSS 0.05326f
C8985 VDD.n1228 VSS 0.06221f
C8986 VDD.n1229 VSS 0.06221f
C8987 VDD.n1230 VSS 0.06221f
C8988 VDD.n1231 VSS 0.06221f
C8989 VDD.n1232 VSS 0.06221f
C8990 VDD.n1233 VSS 0.06221f
C8991 VDD.n1234 VSS 0.06221f
C8992 VDD.t1090 VSS 0.03468f
C8993 VDD.t1780 VSS 0.03305f
C8994 VDD.n1236 VSS 0.03122f
C8995 VDD.t1750 VSS 0.30068f
C8996 VDD.t1089 VSS 0.61031f
C8997 VDD.t106 VSS 0.80181f
C8998 VDD.t72 VSS 0.80181f
C8999 VDD.t345 VSS 0.80181f
C9000 VDD.t1205 VSS 0.80181f
C9001 VDD.t102 VSS 0.80181f
C9002 VDD.t20 VSS 0.80181f
C9003 VDD.t1786 VSS 0.59241f
C9004 VDD.n1241 VSS 0.48696f
C9005 VDD.n1248 VSS 0.09437f
C9006 VDD.n1249 VSS 1.07521f
C9007 VDD.n1250 VSS 1.07521f
C9008 VDD.n1251 VSS 0.09437f
C9009 VDD.n1252 VSS 0.03122f
C9010 VDD.n1253 VSS 0.06221f
C9011 VDD.n1254 VSS 0.06221f
C9012 VDD.n1255 VSS 0.06221f
C9013 VDD.n1256 VSS 0.06221f
C9014 VDD.n1257 VSS 0.06221f
C9015 VDD.n1258 VSS 0.06221f
C9016 VDD.n1259 VSS 0.06221f
C9017 VDD.n1260 VSS 0.05326f
C9018 VDD.n1261 VSS 0.05326f
C9019 VDD.n1262 VSS 0.06221f
C9020 VDD.n1263 VSS 0.06221f
C9021 VDD.n1264 VSS 0.06221f
C9022 VDD.n1265 VSS 0.06221f
C9023 VDD.n1266 VSS 0.06221f
C9024 VDD.n1267 VSS 0.05102f
C9025 VDD.n1268 VSS 0.08045f
C9026 VDD.n1269 VSS 1.07521f
C9027 VDD.n1270 VSS 1.07521f
C9028 VDD.n1271 VSS 0.08045f
C9029 VDD.n1272 VSS 0.0294f
C9030 VDD.n1273 VSS 0.0294f
C9031 VDD.n1274 VSS 0.03122f
C9032 VDD.n1275 VSS 0.06221f
C9033 VDD.n1276 VSS 0.06221f
C9034 VDD.n1277 VSS 0.06221f
C9035 VDD.n1278 VSS 0.06221f
C9036 VDD.n1279 VSS 0.06221f
C9037 VDD.n1280 VSS 0.06221f
C9038 VDD.n1281 VSS 0.06221f
C9039 VDD.n1282 VSS 0.05326f
C9040 VDD.n1283 VSS 0.05326f
C9041 VDD.n1284 VSS 0.06221f
C9042 VDD.n1285 VSS 0.06221f
C9043 VDD.n1286 VSS 0.06221f
C9044 VDD.n1287 VSS 0.06221f
C9045 VDD.n1288 VSS 0.06221f
C9046 VDD.n1289 VSS 0.04282f
C9047 VDD.n1290 VSS 0.08045f
C9048 VDD.n1291 VSS 1.07521f
C9049 VDD.t1946 VSS 0.03468f
C9050 VDD.t702 VSS 0.03305f
C9051 VDD.t1130 VSS 0.03468f
C9052 VDD.t781 VSS 0.03305f
C9053 VDD.t2006 VSS 0.03468f
C9054 VDD.t238 VSS 0.03305f
C9055 VDD.t150 VSS 0.03468f
C9056 VDD.t1186 VSS 0.03305f
C9057 VDD.t1723 VSS 0.03468f
C9058 VDD.t1184 VSS 0.03305f
C9059 VDD.t1952 VSS 0.03468f
C9060 VDD.t265 VSS 0.03305f
C9061 VDD.t756 VSS 0.03468f
C9062 VDD.t1128 VSS 0.03305f
C9063 VDD.t1242 VSS 0.03468f
C9064 VDD.t1126 VSS 0.03305f
C9065 VDD.t171 VSS 0.03468f
C9066 VDD.t698 VSS 0.03305f
C9067 VDD.t1907 VSS 0.03468f
C9068 VDD.t1188 VSS 0.03305f
C9069 VDD.t1757 VSS 0.03468f
C9070 VDD.t2026 VSS 0.03305f
C9071 VDD.t1948 VSS 0.03468f
C9072 VDD.t1125 VSS 0.29173f
C9073 VDD.t170 VSS 0.40091f
C9074 VDD.t697 VSS 0.40091f
C9075 VDD.t1906 VSS 0.40091f
C9076 VDD.t1187 VSS 0.40091f
C9077 VDD.t1756 VSS 0.30963f
C9078 VDD.t2025 VSS 0.1915f
C9079 VDD.t1947 VSS 0.2094f
C9080 VDD.n1305 VSS 0.56929f
C9081 VDD.n1312 VSS 0.04829f
C9082 VDD.n1313 VSS 0.06221f
C9083 VDD.n1314 VSS 0.06221f
C9084 VDD.n1315 VSS 0.06221f
C9085 VDD.t507 VSS 0.03305f
C9086 VDD.t132 VSS 0.03468f
C9087 VDD.t1941 VSS 0.03305f
C9088 VDD.n1318 VSS 0.0294f
C9089 VDD.n1320 VSS 0.03122f
C9090 VDD.t1241 VSS 0.30068f
C9091 VDD.t506 VSS 0.2094f
C9092 VDD.t131 VSS 0.1915f
C9093 VDD.t1940 VSS 0.30963f
C9094 VDD.t1945 VSS 0.40091f
C9095 VDD.t701 VSS 0.40091f
C9096 VDD.t1129 VSS 0.40091f
C9097 VDD.t780 VSS 0.40091f
C9098 VDD.t2005 VSS 0.40091f
C9099 VDD.t237 VSS 0.40091f
C9100 VDD.t149 VSS 0.40091f
C9101 VDD.t1185 VSS 0.40091f
C9102 VDD.t1722 VSS 0.40091f
C9103 VDD.t1183 VSS 0.40091f
C9104 VDD.t1951 VSS 0.40091f
C9105 VDD.t264 VSS 0.40091f
C9106 VDD.t755 VSS 0.29173f
C9107 VDD.t1127 VSS 0.43965f
C9108 VDD.t41 VSS 0.03468f
C9109 VDD.t1911 VSS 0.03305f
C9110 VDD.t1824 VSS 0.03468f
C9111 VDD.t262 VSS 0.03305f
C9112 VDD.t1903 VSS 0.03468f
C9113 VDD.t1943 VSS 0.03305f
C9114 VDD.t177 VSS 0.03468f
C9115 VDD.t23 VSS 0.03305f
C9116 VDD.t81 VSS 0.03468f
C9117 VDD.t2067 VSS 0.03305f
C9118 VDD.t148 VSS 0.03468f
C9119 VDD.t19 VSS 0.03305f
C9120 VDD.t1959 VSS 0.03468f
C9121 VDD.t1036 VSS 0.03305f
C9122 VDD.t117 VSS 0.03468f
C9123 VDD.t380 VSS 0.03305f
C9124 VDD.t47 VSS 0.03468f
C9125 VDD.t364 VSS 0.03305f
C9126 VDD.t1777 VSS 0.03468f
C9127 VDD.t1918 VSS 0.03305f
C9128 VDD.t1725 VSS 0.03468f
C9129 VDD.t700 VSS 0.03305f
C9130 VDD.t175 VSS 0.03468f
C9131 VDD.t464 VSS 0.03305f
C9132 VDD.t1237 VSS 0.03468f
C9133 VDD.t1124 VSS 0.03305f
C9134 VDD.t43 VSS 0.03468f
C9135 VDD.t113 VSS 0.03305f
C9136 VDD.t1826 VSS 0.03468f
C9137 VDD.t31 VSS 0.03305f
C9138 VDD.t1753 VSS 0.03468f
C9139 VDD.t33 VSS 0.03305f
C9140 VDD.t368 VSS 0.03468f
C9141 VDD.t356 VSS 0.03305f
C9142 VDD.t40 VSS 0.40091f
C9143 VDD.t1910 VSS 0.1915f
C9144 VDD.t1823 VSS 0.30963f
C9145 VDD.t261 VSS 0.40091f
C9146 VDD.t1902 VSS 0.40091f
C9147 VDD.t1942 VSS 0.40091f
C9148 VDD.t176 VSS 0.40091f
C9149 VDD.t22 VSS 0.40091f
C9150 VDD.t80 VSS 0.40091f
C9151 VDD.t2066 VSS 0.40091f
C9152 VDD.t147 VSS 0.40091f
C9153 VDD.t18 VSS 0.40091f
C9154 VDD.t1958 VSS 0.40091f
C9155 VDD.t1035 VSS 0.40091f
C9156 VDD.t116 VSS 0.40091f
C9157 VDD.t379 VSS 0.29173f
C9158 VDD.t46 VSS 0.40986f
C9159 VDD.t363 VSS 0.40091f
C9160 VDD.t1776 VSS 0.1915f
C9161 VDD.t1917 VSS 0.30963f
C9162 VDD.t1724 VSS 0.40091f
C9163 VDD.t699 VSS 0.40091f
C9164 VDD.t174 VSS 0.40091f
C9165 VDD.t463 VSS 0.40091f
C9166 VDD.t1236 VSS 0.40091f
C9167 VDD.t1123 VSS 0.40091f
C9168 VDD.t42 VSS 0.40091f
C9169 VDD.t112 VSS 0.40091f
C9170 VDD.t1825 VSS 0.40091f
C9171 VDD.t30 VSS 0.40091f
C9172 VDD.t1752 VSS 0.40091f
C9173 VDD.t32 VSS 0.40091f
C9174 VDD.t367 VSS 0.29173f
C9175 VDD.t355 VSS 0.43965f
C9176 VDD.t1729 VSS 0.03468f
C9177 VDD.t109 VSS 0.03305f
C9178 VDD.t181 VSS 0.03468f
C9179 VDD.t322 VSS 0.03305f
C9180 VDD.t201 VSS 0.03468f
C9181 VDD.t115 VSS 0.03305f
C9182 VDD.t1749 VSS 0.03468f
C9183 VDD.t79 VSS 0.03305f
C9184 VDD.t2069 VSS 0.03468f
C9185 VDD.t77 VSS 0.03305f
C9186 VDD.t120 VSS 0.03468f
C9187 VDD.t136 VSS 0.03305f
C9188 VDD.t1727 VSS 0.03468f
C9189 VDD.t29 VSS 0.03305f
C9190 VDD.t1240 VSS 0.03468f
C9191 VDD.t111 VSS 0.03305f
C9192 VDD.t89 VSS 0.03468f
C9193 VDD.t1238 VSS 0.03468f
C9194 VDD.t27 VSS 0.03305f
C9195 VDD.t336 VSS 0.03468f
C9196 VDD.t138 VSS 0.03305f
C9197 VDD.t750 VSS 0.03468f
C9198 VDD.t335 VSS 0.03305f
C9199 VDD.t51 VSS 0.03468f
C9200 VDD.t1219 VSS 0.03305f
C9201 VDD.t169 VSS 0.03468f
C9202 VDD.t105 VSS 0.03305f
C9203 VDD.t867 VSS 0.03468f
C9204 VDD.t1781 VSS 0.03305f
C9205 VDD.t1944 VSS 0.03468f
C9206 VDD.t37 VSS 0.03305f
C9207 VDD.t203 VSS 0.03468f
C9208 VDD.t263 VSS 0.03305f
C9209 VDD.t1728 VSS 0.40091f
C9210 VDD.t108 VSS 0.1915f
C9211 VDD.t180 VSS 0.30963f
C9212 VDD.t321 VSS 0.40091f
C9213 VDD.t200 VSS 0.40091f
C9214 VDD.t114 VSS 0.40091f
C9215 VDD.t1748 VSS 0.40091f
C9216 VDD.t78 VSS 0.40091f
C9217 VDD.t2068 VSS 0.40091f
C9218 VDD.t76 VSS 0.40091f
C9219 VDD.t119 VSS 0.40091f
C9220 VDD.t135 VSS 0.40091f
C9221 VDD.t1726 VSS 0.40091f
C9222 VDD.t28 VSS 0.40091f
C9223 VDD.t1239 VSS 0.40091f
C9224 VDD.t110 VSS 0.29173f
C9225 VDD.t88 VSS 0.30068f
C9226 VDD.t26 VSS 0.61031f
C9227 VDD.t137 VSS 0.80181f
C9228 VDD.t334 VSS 0.80181f
C9229 VDD.t50 VSS 0.80181f
C9230 VDD.t104 VSS 0.80181f
C9231 VDD.t866 VSS 0.80181f
C9232 VDD.t36 VSS 0.80181f
C9233 VDD.t202 VSS 0.59241f
C9234 VDD.n1370 VSS 0.48696f
C9235 VDD.n1377 VSS 0.09437f
C9236 VDD.n1378 VSS 0.03122f
C9237 VDD.n1379 VSS 0.06221f
C9238 VDD.n1380 VSS 0.06221f
C9239 VDD.n1381 VSS 0.06221f
C9240 VDD.n1382 VSS 0.06221f
C9241 VDD.n1383 VSS 0.06221f
C9242 VDD.n1384 VSS 0.06221f
C9243 VDD.n1385 VSS 0.06221f
C9244 VDD.n1386 VSS 0.05326f
C9245 VDD.n1387 VSS 0.05326f
C9246 VDD.n1388 VSS 0.06221f
C9247 VDD.n1389 VSS 0.06221f
C9248 VDD.n1390 VSS 0.06221f
C9249 VDD.n1391 VSS 0.06221f
C9250 VDD.n1392 VSS 0.06221f
C9251 VDD.n1393 VSS 0.05102f
C9252 VDD.n1394 VSS 0.08045f
C9253 VDD.n1395 VSS 0.0294f
C9254 VDD.n1396 VSS 0.0294f
C9255 VDD.n1397 VSS 0.03122f
C9256 VDD.n1398 VSS 0.06221f
C9257 VDD.n1399 VSS 0.06221f
C9258 VDD.n1400 VSS 0.06221f
C9259 VDD.n1401 VSS 0.06221f
C9260 VDD.n1402 VSS 0.06221f
C9261 VDD.n1403 VSS 0.06221f
C9262 VDD.n1404 VSS 0.06221f
C9263 VDD.n1405 VSS 0.05326f
C9264 VDD.n1406 VSS 0.05326f
C9265 VDD.n1407 VSS 0.06221f
C9266 VDD.n1408 VSS 0.06221f
C9267 VDD.n1409 VSS 0.06221f
C9268 VDD.n1410 VSS 0.06221f
C9269 VDD.n1411 VSS 0.06221f
C9270 VDD.n1412 VSS 0.04282f
C9271 VDD.n1413 VSS 0.08045f
C9272 VDD.n1414 VSS 1.07521f
C9273 VDD.t885 VSS 0.03468f
C9274 VDD.t738 VSS 0.03305f
C9275 VDD.t185 VSS 0.03468f
C9276 VDD.t1888 VSS 0.03305f
C9277 VDD.t3 VSS 0.03468f
C9278 VDD.t736 VSS 0.03305f
C9279 VDD.t890 VSS 0.03468f
C9280 VDD.t164 VSS 0.03305f
C9281 VDD.t360 VSS 0.03468f
C9282 VDD.t162 VSS 0.03305f
C9283 VDD.t158 VSS 0.03468f
C9284 VDD.t1992 VSS 0.03305f
C9285 VDD.t728 VSS 0.03468f
C9286 VDD.t1809 VSS 0.03305f
C9287 VDD.t294 VSS 0.03468f
C9288 VDD.t1798 VSS 0.03305f
C9289 VDD.t296 VSS 0.03468f
C9290 VDD.t300 VSS 0.03305f
C9291 VDD.t493 VSS 0.03468f
C9292 VDD.t1990 VSS 0.03305f
C9293 VDD.t271 VSS 0.03468f
C9294 VDD.t710 VSS 0.03305f
C9295 VDD.t187 VSS 0.03468f
C9296 VDD.t1797 VSS 0.29173f
C9297 VDD.t295 VSS 0.40091f
C9298 VDD.t299 VSS 0.40091f
C9299 VDD.t492 VSS 0.40091f
C9300 VDD.t1989 VSS 0.40091f
C9301 VDD.t270 VSS 0.30963f
C9302 VDD.t709 VSS 0.1915f
C9303 VDD.t186 VSS 0.2094f
C9304 VDD.n1428 VSS 0.56929f
C9305 VDD.n1435 VSS 0.04829f
C9306 VDD.n1436 VSS 0.06221f
C9307 VDD.n1437 VSS 0.06221f
C9308 VDD.n1438 VSS 0.06221f
C9309 VDD.t179 VSS 0.03305f
C9310 VDD.t1805 VSS 0.03468f
C9311 VDD.t708 VSS 0.03305f
C9312 VDD.n1441 VSS 0.0294f
C9313 VDD.n1443 VSS 0.03122f
C9314 VDD.t293 VSS 0.30068f
C9315 VDD.t178 VSS 0.2094f
C9316 VDD.t1804 VSS 0.1915f
C9317 VDD.t707 VSS 0.30963f
C9318 VDD.t884 VSS 0.40091f
C9319 VDD.t737 VSS 0.40091f
C9320 VDD.t184 VSS 0.40091f
C9321 VDD.t1887 VSS 0.40091f
C9322 VDD.t2 VSS 0.40091f
C9323 VDD.t735 VSS 0.40091f
C9324 VDD.t889 VSS 0.40091f
C9325 VDD.t163 VSS 0.40091f
C9326 VDD.t359 VSS 0.40091f
C9327 VDD.t161 VSS 0.40091f
C9328 VDD.t157 VSS 0.40091f
C9329 VDD.t1991 VSS 0.40091f
C9330 VDD.t727 VSS 0.29173f
C9331 VDD.t1808 VSS 0.43965f
C9332 VDD.t491 VSS 0.03468f
C9333 VDD.t1893 VSS 0.03305f
C9334 VDD.t852 VSS 0.03468f
C9335 VDD.t13 VSS 0.03305f
C9336 VDD.t1122 VSS 0.03468f
C9337 VDD.t69 VSS 0.03305f
C9338 VDD.t602 VSS 0.03468f
C9339 VDD.t1256 VSS 0.03305f
C9340 VDD.t1939 VSS 0.03468f
C9341 VDD.t189 VSS 0.03305f
C9342 VDD.t1182 VSS 0.03468f
C9343 VDD.t895 VSS 0.03305f
C9344 VDD.t501 VSS 0.03468f
C9345 VDD.t1818 VSS 0.03305f
C9346 VDD.t785 VSS 0.03468f
C9347 VDD.t412 VSS 0.03305f
C9348 VDD.t1192 VSS 0.03468f
C9349 VDD.t490 VSS 0.40091f
C9350 VDD.t1892 VSS 0.1915f
C9351 VDD.t851 VSS 0.30963f
C9352 VDD.t12 VSS 0.40091f
C9353 VDD.t1121 VSS 0.40091f
C9354 VDD.t68 VSS 0.40091f
C9355 VDD.t601 VSS 0.40091f
C9356 VDD.t1255 VSS 0.40091f
C9357 VDD.t1938 VSS 0.40091f
C9358 VDD.t188 VSS 0.40091f
C9359 VDD.t1181 VSS 0.40091f
C9360 VDD.t894 VSS 0.40091f
C9361 VDD.t500 VSS 0.40091f
C9362 VDD.t1817 VSS 0.40091f
C9363 VDD.t784 VSS 0.40091f
C9364 VDD.t411 VSS 0.29173f
C9365 VDD.t1483 VSS 0.29173f
C9366 VDD.t1260 VSS 0.40091f
C9367 VDD.t1189 VSS 0.40091f
C9368 VDD.t133 VSS 0.40091f
C9369 VDD.t1222 VSS 0.40091f
C9370 VDD.t361 VSS 0.40091f
C9371 VDD.t514 VSS 0.40091f
C9372 VDD.t1251 VSS 0.40091f
C9373 VDD.t323 VSS 0.40091f
C9374 VDD.t887 VSS 0.40091f
C9375 VDD.t1997 VSS 0.40091f
C9376 VDD.t721 VSS 0.40091f
C9377 VDD.t2020 VSS 0.40091f
C9378 VDD.t259 VSS 0.30963f
C9379 VDD.t2027 VSS 0.1915f
C9380 VDD.t301 VSS 0.40091f
C9381 VDD.t1191 VSS 0.40986f
C9382 VDD.t302 VSS 0.03305f
C9383 VDD.t2028 VSS 0.03468f
C9384 VDD.t260 VSS 0.03305f
C9385 VDD.n1464 VSS 0.0294f
C9386 VDD.n1465 VSS 0.0294f
C9387 VDD.n1466 VSS 0.03122f
C9388 VDD.n1467 VSS 0.06221f
C9389 VDD.n1468 VSS 0.06221f
C9390 VDD.n1469 VSS 0.06221f
C9391 VDD.n1470 VSS 0.06221f
C9392 VDD.n1471 VSS 0.06221f
C9393 VDD.n1472 VSS 0.06221f
C9394 VDD.n1473 VSS 0.06221f
C9395 VDD.n1474 VSS 0.05326f
C9396 VDD.n1475 VSS 0.05326f
C9397 VDD.n1476 VSS 0.06221f
C9398 VDD.n1477 VSS 0.06221f
C9399 VDD.n1478 VSS 0.06221f
C9400 VDD.n1479 VSS 0.06221f
C9401 VDD.n1480 VSS 0.06221f
C9402 VDD.n1481 VSS 0.04282f
C9403 VDD.n1482 VSS 0.08045f
C9404 VDD.n1483 VSS 1.07521f
C9405 VDD.n1484 VSS 0.83525f
C9406 VDD.n1485 VSS 0.08045f
C9407 VDD.n1486 VSS 0.05724f
C9408 VDD.n1487 VSS 0.06221f
C9409 VDD.n1488 VSS 0.05381f
C9410 VDD.n1489 VSS 0.05138f
C9411 VDD.n1490 VSS 0.03122f
C9412 VDD.t744 VSS 0.03305f
C9413 VDD.n1492 VSS 0.04332f
C9414 VDD.n1498 VSS 0.2094f
C9415 VDD.t1264 VSS 0.30068f
C9416 VDD.t743 VSS 0.40091f
C9417 VDD.t239 VSS 0.40091f
C9418 VDD.t1262 VSS 0.40091f
C9419 VDD.t1821 VSS 0.40091f
C9420 VDD.t286 VSS 0.40091f
C9421 VDD.t1851 VSS 0.40091f
C9422 VDD.t413 VSS 0.40091f
C9423 VDD.t291 VSS 0.40091f
C9424 VDD.t10 VSS 0.40091f
C9425 VDD.t705 VSS 0.40091f
C9426 VDD.t875 VSS 0.40091f
C9427 VDD.t1795 VSS 0.40091f
C9428 VDD.t1269 VSS 0.40091f
C9429 VDD.t1258 VSS 0.39196f
C9430 VDD.t1806 VSS 0.10918f
C9431 VDD.n1499 VSS 0.2213f
C9432 VDD.t892 VSS 0.03468f
C9433 VDD.t155 VSS 0.40091f
C9434 VDD.t16 VSS 0.40091f
C9435 VDD.t282 VSS 0.40091f
C9436 VDD.t330 VSS 0.40091f
C9437 VDD.t1860 VSS 0.40091f
C9438 VDD.t1815 VSS 0.40091f
C9439 VDD.t317 VSS 0.40091f
C9440 VDD.t1799 VSS 0.40091f
C9441 VDD.t231 VSS 0.40091f
C9442 VDD.t719 VSS 0.40091f
C9443 VDD.t274 VSS 0.40091f
C9444 VDD.t332 VSS 0.40091f
C9445 VDD.t723 VSS 0.40091f
C9446 VDD.t1247 VSS 0.2094f
C9447 VDD.t891 VSS 0.29173f
C9448 VDD.n1504 VSS 0.2094f
C9449 VDD.t1248 VSS 0.03305f
C9450 VDD.t724 VSS 0.03468f
C9451 VDD.t333 VSS 0.03305f
C9452 VDD.t275 VSS 0.03468f
C9453 VDD.t720 VSS 0.03305f
C9454 VDD.t232 VSS 0.03468f
C9455 VDD.t1800 VSS 0.03305f
C9456 VDD.t318 VSS 0.03468f
C9457 VDD.t1816 VSS 0.03305f
C9458 VDD.t1861 VSS 0.03468f
C9459 VDD.t331 VSS 0.03305f
C9460 VDD.t283 VSS 0.03468f
C9461 VDD.t17 VSS 0.03305f
C9462 VDD.t156 VSS 0.03468f
C9463 VDD.t488 VSS 0.03305f
C9464 VDD.t1814 VSS 0.03468f
C9465 VDD.n1515 VSS 0.06221f
C9466 VDD.n1516 VSS 0.06221f
C9467 VDD.n1517 VSS 0.06221f
C9468 VDD.n1518 VSS 0.06221f
C9469 VDD.n1519 VSS 0.06221f
C9470 VDD.n1520 VSS 0.06221f
C9471 VDD.n1521 VSS 0.06221f
C9472 VDD.n1522 VSS 0.03437f
C9473 VDD.n1524 VSS 0.05326f
C9474 VDD.n1525 VSS 0.06221f
C9475 VDD.n1526 VSS 0.06221f
C9476 VDD.n1527 VSS 0.06221f
C9477 VDD.n1528 VSS 0.06221f
C9478 VDD.n1529 VSS 0.06221f
C9479 VDD.n1530 VSS 0.05102f
C9480 VDD.n1531 VSS 0.06653f
C9481 VDD.n1532 VSS 0.83525f
C9482 VDD.n1533 VSS 1.07521f
C9483 VDD.n1534 VSS 0.08045f
C9484 VDD.n1535 VSS 0.05102f
C9485 VDD.n1536 VSS 0.06221f
C9486 VDD.n1537 VSS 0.06221f
C9487 VDD.n1538 VSS 0.06221f
C9488 VDD.n1539 VSS 0.06221f
C9489 VDD.n1540 VSS 0.06221f
C9490 VDD.n1541 VSS 0.05326f
C9491 VDD.n1542 VSS 0.05326f
C9492 VDD.n1543 VSS 0.06221f
C9493 VDD.n1544 VSS 0.06221f
C9494 VDD.n1545 VSS 0.06221f
C9495 VDD.n1546 VSS 0.06221f
C9496 VDD.n1547 VSS 0.06221f
C9497 VDD.n1548 VSS 0.06221f
C9498 VDD.n1549 VSS 0.06221f
C9499 VDD.t505 VSS 0.03468f
C9500 VDD.t1257 VSS 0.03305f
C9501 VDD.n1551 VSS 0.03122f
C9502 VDD.t1179 VSS 0.30068f
C9503 VDD.t504 VSS 0.61031f
C9504 VDD.t782 VSS 0.80181f
C9505 VDD.t248 VSS 0.80181f
C9506 VDD.t389 VSS 0.80181f
C9507 VDD.t373 VSS 0.80181f
C9508 VDD.t423 VSS 0.80181f
C9509 VDD.t246 VSS 0.80181f
C9510 VDD.t485 VSS 0.59241f
C9511 VDD.n1556 VSS 0.48696f
C9512 VDD.n1563 VSS 0.09437f
C9513 VDD.n1564 VSS 1.07521f
C9514 VDD.n1565 VSS 0.83525f
C9515 VDD.n1566 VSS 0.09437f
C9516 VDD.n1567 VSS 0.03122f
C9517 VDD.n1572 VSS 0.40091f
C9518 VDD.t1813 VSS 0.10918f
C9519 avo[5].t2 VSS 0.02711f
C9520 avo[5].t1 VSS 0.02711f
C9521 avo[5].n0 VSS 0.05449f
C9522 avo[5].t0 VSS 0.07646f
C9523 avo[5].n1 VSS 0.08816f
C9524 avo[5].t3 VSS 0.10147f
C9525 avo[5].n2 VSS 0.08892f
C9526 avo[5].t5 VSS 0.05586f
C9527 avo[5].t4 VSS 0.04034f
C9528 avo[5].n3 VSS 0.0962f
C9529 avo[5].n4 VSS 0.09458f
C9530 avo[5].t7 VSS 0.12463f
C9531 avo[5].t6 VSS 0.06565f
C9532 avo[5].n5 VSS 0.14635f
C9533 avo[5].n6 VSS 0.07806f
C9534 avo[5].n7 VSS 0.03961f
C9535 avo[5].n8 VSS 0.46402f
C9536 avo[5].n9 VSS 0.17335f
C9537 avo[5].n10 VSS 0.08813f
C9538 uio_oe[7].t0 VSS 0.03782f
C9539 uio_oe[7].n0 VSS 0.11993f
C9540 uio_oe[6].t0 VSS 0.06042f
C9541 uio_oe[6].n0 VSS 0.12181f
C9542 uio_oe[5].t0 VSS 0.06076f
C9543 uio_oe[5].n0 VSS 0.12248f
C9544 uio_oe[4].t0 VSS 0.05431f
C9545 uio_oe[4].n0 VSS 0.15811f
C9546 uio_oe[3].t0 VSS 0.0578f
C9547 uio_oe[3].n0 VSS 0.11653f
C9548 uio_oe[2].t0 VSS 0.06134f
C9549 uio_oe[2].n0 VSS 0.12366f
C9550 uio_oe[1].t0 VSS 0.06015f
C9551 uio_oe[1].n0 VSS 0.12125f
C9552 uio_oe[0].t0 VSS 0.05682f
C9553 uio_oe[0].n0 VSS 0.11454f
C9554 dvo[4].t7 VSS 0.12596f
C9555 dvo[4].t6 VSS 0.06635f
C9556 dvo[4].n0 VSS 0.14791f
C9557 dvo[4].n1 VSS 0.0789f
C9558 dvo[4].t1 VSS 0.0274f
C9559 dvo[4].t0 VSS 0.0274f
C9560 dvo[4].n2 VSS 0.05507f
C9561 dvo[4].t2 VSS 0.07727f
C9562 dvo[4].n3 VSS 0.07159f
C9563 dvo[4].t5 VSS 0.10255f
C9564 dvo[4].n4 VSS 0.08987f
C9565 dvo[4].n5 VSS 0.08792f
C9566 dvo[4].t4 VSS 0.04077f
C9567 dvo[4].t3 VSS 0.05645f
C9568 dvo[4].n6 VSS 0.09722f
C9569 dvo[4].n8 VSS 0.06424f
C9570 dvo[4].n9 VSS 0.12958f
C9571 dvo[4].n10 VSS 0.8186f
C9572 dvo[4].n11 VSS 0.04003f
C9573 dvo[5].t7 VSS 0.11994f
C9574 dvo[5].t6 VSS 0.06318f
C9575 dvo[5].n0 VSS 0.14085f
C9576 dvo[5].n1 VSS 0.03235f
C9577 dvo[5].t2 VSS 0.02609f
C9578 dvo[5].t1 VSS 0.02609f
C9579 dvo[5].n2 VSS 0.05244f
C9580 dvo[5].t5 VSS 0.05376f
C9581 dvo[5].t4 VSS 0.03882f
C9582 dvo[5].n3 VSS 0.09258f
C9583 dvo[5].n4 VSS 0.1115f
C9584 dvo[5].t3 VSS 0.09765f
C9585 dvo[5].n5 VSS 0.08557f
C9586 dvo[5].n6 VSS 0.19081f
C9587 dvo[5].n7 VSS 0.08485f
C9588 dvo[5].t0 VSS 0.07334f
C9589 dvo[5].n8 VSS 0.07242f
C9590 dvo[5].n9 VSS 0.9947f
C9591 dvo[5].n10 VSS 0.12862f
C9592 avo[4].t1 VSS 0.02605f
C9593 avo[4].t0 VSS 0.02605f
C9594 avo[4].n0 VSS 0.05236f
C9595 avo[4].t4 VSS 0.03876f
C9596 avo[4].t3 VSS 0.05367f
C9597 avo[4].n1 VSS 0.09243f
C9598 avo[4].n3 VSS 0.11276f
C9599 avo[4].t5 VSS 0.09749f
C9600 avo[4].n4 VSS 0.08544f
C9601 avo[4].n5 VSS 0.13032f
C9602 avo[4].n6 VSS 0.06806f
C9603 avo[4].t2 VSS 0.07322f
C9604 avo[4].n7 VSS 0.09011f
C9605 avo[4].n8 VSS 1.03032f
C9606 avo[4].t7 VSS 0.06308f
C9607 avo[4].t6 VSS 0.11975f
C9608 avo[4].n9 VSS 0.14062f
C9609 avo[4].n10 VSS 0.14671f
C9610 dvo[1].t4 VSS 0.03784f
C9611 dvo[1].t3 VSS 0.05239f
C9612 dvo[1].n0 VSS 0.09023f
C9613 dvo[1].t1 VSS 0.02543f
C9614 dvo[1].t0 VSS 0.02543f
C9615 dvo[1].n2 VSS 0.05111f
C9616 dvo[1].t2 VSS 0.07172f
C9617 dvo[1].n3 VSS 0.06644f
C9618 dvo[1].t5 VSS 0.09517f
C9619 dvo[1].n4 VSS 0.0834f
C9620 dvo[1].n5 VSS 0.11165f
C9621 dvo[1].t7 VSS 0.06158f
C9622 dvo[1].t6 VSS 0.1169f
C9623 dvo[1].n6 VSS 0.13727f
C9624 dvo[1].n7 VSS 0.09078f
C9625 dvo[1].n8 VSS 0.05179f
C9626 dvo[1].n9 VSS 1.10768f
C9627 dvo[1].n10 VSS 0.40532f
C9628 dvo[1].n11 VSS 0.02956f
C9629 dvo[0].t2 VSS 0.04879f
C9630 dvo[0].t3 VSS 0.03523f
C9631 dvo[0].n0 VSS 0.08402f
C9632 dvo[0].n1 VSS 0.05792f
C9633 dvo[0].n2 VSS 0.04759f
C9634 dvo[0].n3 VSS 0.03898f
C9635 dvo[0].n4 VSS 0.75218f
C9636 avo[0].t1 VSS 0.0312f
C9637 avo[0].t0 VSS 0.0432f
C9638 avo[0].n0 VSS 0.07441f
C9639 avo[0].n2 VSS 0.05206f
C9640 avo[0].n3 VSS 0.04215f
C9641 avo[0].n4 VSS 0.72685f
C9642 avo[1].t7 VSS 0.09476f
C9643 avo[1].t6 VSS 0.04992f
C9644 avo[1].n0 VSS 0.11127f
C9645 avo[1].n1 VSS 0.02556f
C9646 avo[1].t5 VSS 0.04247f
C9647 avo[1].t4 VSS 0.03067f
C9648 avo[1].n2 VSS 0.07421f
C9649 avo[1].n3 VSS 0.04123f
C9650 avo[1].n4 VSS 0.05626f
C9651 avo[1].t0 VSS 0.05794f
C9652 avo[1].n5 VSS 0.03959f
C9653 avo[1].n6 VSS 0.07168f
C9654 avo[1].n7 VSS 0.12836f
C9655 avo[1].t3 VSS 0.07714f
C9656 avo[1].n8 VSS 0.10861f
C9657 avo[1].n9 VSS 0.76502f
C9658 avo[1].n10 VSS 0.08968f
C9659 dvo[2].t1 VSS 0.04394f
C9660 dvo[2].t0 VSS 0.03173f
C9661 dvo[2].n0 VSS 0.07567f
C9662 dvo[2].n1 VSS 0.09113f
C9663 dvo[2].n2 VSS 0.04286f
C9664 dvo[2].t3 VSS 0.06014f
C9665 dvo[2].n3 VSS 0.06935f
C9666 dvo[2].n4 VSS 0.15595f
C9667 dvo[2].t2 VSS 0.07981f
C9668 dvo[2].n5 VSS 0.05196f
C9669 dvo[2].t7 VSS 0.05164f
C9670 dvo[2].t6 VSS 0.09803f
C9671 dvo[2].n6 VSS 0.11512f
C9672 dvo[2].n8 VSS 0.08577f
C9673 dvo[2].n9 VSS 1.65077f
C9674 dvo[2].n10 VSS 0.24618f
C9675 avo[2].t7 VSS 0.07182f
C9676 avo[2].t6 VSS 0.13633f
C9677 avo[2].n0 VSS 0.1601f
C9678 avo[2].t4 VSS 0.02966f
C9679 avo[2].t3 VSS 0.02966f
C9680 avo[2].n1 VSS 0.05932f
C9681 avo[2].n2 VSS 0.08095f
C9682 avo[2].t5 VSS 0.0611f
C9683 avo[2].t1 VSS 0.04413f
C9684 avo[2].n3 VSS 0.10677f
C9685 avo[2].t0 VSS 0.11241f
C9686 avo[2].n4 VSS 0.18467f
C9687 avo[2].n5 VSS 0.10313f
C9688 avo[2].t2 VSS 0.08336f
C9689 avo[2].n6 VSS 0.03518f
C9690 avo[2].n7 VSS 0.02542f
C9691 avo[2].n8 VSS 3.11028f
C9692 avo[2].n9 VSS 0.54419f
C9693 avo[3].t5 VSS 0.02997f
C9694 avo[3].t4 VSS 0.02997f
C9695 avo[3].n0 VSS 0.05993f
C9696 avo[3].n1 VSS 0.08178f
C9697 avo[3].t1 VSS 0.06173f
C9698 avo[3].t0 VSS 0.04458f
C9699 avo[3].n2 VSS 0.10788f
C9700 avo[3].t2 VSS 0.11358f
C9701 avo[3].n3 VSS 0.18659f
C9702 avo[3].n4 VSS 0.1042f
C9703 avo[3].t3 VSS 0.08422f
C9704 avo[3].n5 VSS 0.03555f
C9705 avo[3].t7 VSS 0.07256f
C9706 avo[3].t6 VSS 0.13774f
C9707 avo[3].n6 VSS 0.16176f
C9708 avo[3].n7 VSS 0.08334f
C9709 avo[3].n8 VSS 0.051f
C9710 avo[3].n9 VSS 3.40207f
C9711 avo[3].n10 VSS 0.22752f
C9712 dvo[3].t7 VSS 0.12465f
C9713 dvo[3].t6 VSS 0.06567f
C9714 dvo[3].n0 VSS 0.14638f
C9715 dvo[3].n1 VSS 0.07808f
C9716 dvo[3].t5 VSS 0.05587f
C9717 dvo[3].t4 VSS 0.04035f
C9718 dvo[3].n2 VSS 0.09621f
C9719 dvo[3].n3 VSS 0.0946f
C9720 dvo[3].t2 VSS 0.02712f
C9721 dvo[3].t1 VSS 0.02712f
C9722 dvo[3].n4 VSS 0.0545f
C9723 dvo[3].t0 VSS 0.07647f
C9724 dvo[3].n5 VSS 0.08818f
C9725 dvo[3].t3 VSS 0.10148f
C9726 dvo[3].n6 VSS 0.08893f
C9727 dvo[3].n7 VSS 0.08815f
C9728 dvo[3].n8 VSS 0.15721f
C9729 dvo[3].n9 VSS 2.87902f
C9730 dvo[3].n10 VSS 0.03961f
C9731 dac_vco_in.t1 VSS 0.08257f
C9732 dac_vco_in.t0 VSS 0.0408f
C9733 dac_vco_in.n0 VSS 0.12787f
C9734 dac_vco_in.n1 VSS 0.31355f
C9735 ana_vco_in.t1 VSS 0.0933f
C9736 ana_vco_in.t0 VSS 0.0461f
C9737 ana_vco_in.n0 VSS 0.14449f
C9738 ana_vco_in.n1 VSS 0.21932f
.ends
